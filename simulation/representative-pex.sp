* SRAM_CORE ideal-control functional verification
.option post=2 probe ingold=2 numdgt=8 measdgt=8 delmax=5.0p
.temp 25
.width out=200
.include "@MODELS@/NMOS_VTL.inc"
.include "@MODELS@/PMOS_VTL.inc"
.include "pex/SRAM_INTEGRATED.pex.sp"
.include "simulation/common/peripherals.sp"
XDUT 0 vdd in<15> in<14> in<13> in<12> in<11> in<10> in<9> in<8> in<7> in<6> in<5> in<4> in<3> in<2> in<1> in<0> col_sel_b<3> col_sel_b<2> col_sel_b<1> col_sel_b<0> col_sel<3> col_sel<2> col_sel<1> col_sel<0> pre_b dlb<7> dlb<6> dlb<5> dlb<4> dlb<3> dlb<2> dlb<1> dlb<0> dl<7> dl<6> dl<5> dl<4> dl<3> dl<2> dl<1> dl<0> SRAM_INTEGRATED
XWRITE din<0> din<1> din<2> din<3> din<4> din<5> din<6> din<7> dl<0> dl<1> dl<2> dl<3> dl<4> dl<5> dl<6> dl<7> dlb<0> dlb<1> dlb<2> dlb<3> dlb<4> dlb<5> dlb<6> dlb<7> vdd 0 we web write_x8
XREAD dl<0> dl<1> dl<2> dl<3> dl<4> dl<5> dl<6> dl<7> dlb<0> dlb<1> dlb<2> dlb<3> dlb<4> dlb<5> dlb<6> dlb<7> dout<0> dout<1> dout<2> dout<3> dout<4> dout<5> dout<6> dout<7> sae vdd 0 read_x8
C_OUT0 dout<0> 0 10f
C_OUT1 dout<1> 0 10f
C_OUT2 dout<2> 0 10f
C_OUT3 dout<3> 0 10f
C_OUT4 dout<4> 0 10f
C_OUT5 dout<5> 0 10f
C_OUT6 dout<6> 0 10f
C_OUT7 dout<7> 0 10f
.ic v(xdut.n_xarray/xi15/xi5/net2_xarray/xi15/xi5/mm0_g)=0
.ic v(xdut.n_xarray/xi15/xi5/net4_xarray/xi15/xi5/mm1_g)=0.8
.ic v(xdut.n_xarray/xi15/xi9/net2_xarray/xi15/xi9/mm0_g)=0
.ic v(xdut.n_xarray/xi15/xi9/net4_xarray/xi15/xi9/mm1_g)=0.8
.ic v(xdut.n_xarray/xi15/xi13/net2_xarray/xi15/xi13/mm0_g)=0
.ic v(xdut.n_xarray/xi15/xi13/net4_xarray/xi15/xi13/mm1_g)=0.8
.ic v(xdut.n_xarray/xi15/xi17/net2_xarray/xi15/xi17/mm0_g)=0
.ic v(xdut.n_xarray/xi15/xi17/net4_xarray/xi15/xi17/mm1_g)=0.8
.ic v(xdut.n_xarray/xi15/xi21/net2_xarray/xi15/xi21/mm0_g)=0
.ic v(xdut.n_xarray/xi15/xi21/net4_xarray/xi15/xi21/mm1_g)=0.8
.ic v(xdut.n_xarray/xi15/xi25/net2_xarray/xi15/xi25/mm0_g)=0
.ic v(xdut.n_xarray/xi15/xi25/net4_xarray/xi15/xi25/mm1_g)=0.8
.ic v(xdut.n_xarray/xi15/xi29/net2_xarray/xi15/xi29/mm0_g)=0
.ic v(xdut.n_xarray/xi15/xi29/net4_xarray/xi15/xi29/mm1_g)=0.8
.ic v(xdut.n_xarray/xi15/xi33/net2_xarray/xi15/xi33/mm0_g)=0
.ic v(xdut.n_xarray/xi15/xi33/net4_xarray/xi15/xi33/mm1_g)=0.8
.ic v(xdut.n_xarray/xi15/xi6/net2_xarray/xi15/xi6/mm0_g)=0
.ic v(xdut.n_xarray/xi15/xi6/net4_xarray/xi15/xi6/mm1_g)=0.8
.ic v(xdut.n_xarray/xi15/xi10/net2_xarray/xi15/xi10/mm0_g)=0
.ic v(xdut.n_xarray/xi15/xi10/net4_xarray/xi15/xi10/mm1_g)=0.8
.ic v(xdut.n_xarray/xi15/xi14/net2_xarray/xi15/xi14/mm0_g)=0
.ic v(xdut.n_xarray/xi15/xi14/net4_xarray/xi15/xi14/mm1_g)=0.8
.ic v(xdut.n_xarray/xi15/xi18/net2_xarray/xi15/xi18/mm0_g)=0
.ic v(xdut.n_xarray/xi15/xi18/net4_xarray/xi15/xi18/mm1_g)=0.8
.ic v(xdut.n_xarray/xi15/xi22/net2_xarray/xi15/xi22/mm0_g)=0
.ic v(xdut.n_xarray/xi15/xi22/net4_xarray/xi15/xi22/mm1_g)=0.8
.ic v(xdut.n_xarray/xi15/xi26/net2_xarray/xi15/xi26/mm0_g)=0
.ic v(xdut.n_xarray/xi15/xi26/net4_xarray/xi15/xi26/mm1_g)=0.8
.ic v(xdut.n_xarray/xi15/xi30/net2_xarray/xi15/xi30/mm0_g)=0
.ic v(xdut.n_xarray/xi15/xi30/net4_xarray/xi15/xi30/mm1_g)=0.8
.ic v(xdut.n_xarray/xi15/xi34/net2_xarray/xi15/xi34/mm0_g)=0
.ic v(xdut.n_xarray/xi15/xi34/net4_xarray/xi15/xi34/mm1_g)=0.8
.ic v(xdut.n_xarray/xi15/xi7/net2_xarray/xi15/xi7/mm0_g)=0
.ic v(xdut.n_xarray/xi15/xi7/net4_xarray/xi15/xi7/mm1_g)=0.8
.ic v(xdut.n_xarray/xi15/xi11/net2_xarray/xi15/xi11/mm0_g)=0
.ic v(xdut.n_xarray/xi15/xi11/net4_xarray/xi15/xi11/mm1_g)=0.8
.ic v(xdut.n_xarray/xi15/xi15/net2_xarray/xi15/xi15/mm0_g)=0
.ic v(xdut.n_xarray/xi15/xi15/net4_xarray/xi15/xi15/mm1_g)=0.8
.ic v(xdut.n_xarray/xi15/xi19/net2_xarray/xi15/xi19/mm0_g)=0
.ic v(xdut.n_xarray/xi15/xi19/net4_xarray/xi15/xi19/mm1_g)=0.8
.ic v(xdut.n_xarray/xi15/xi23/net2_xarray/xi15/xi23/mm0_g)=0
.ic v(xdut.n_xarray/xi15/xi23/net4_xarray/xi15/xi23/mm1_g)=0.8
.ic v(xdut.n_xarray/xi15/xi27/net2_xarray/xi15/xi27/mm0_g)=0
.ic v(xdut.n_xarray/xi15/xi27/net4_xarray/xi15/xi27/mm1_g)=0.8
.ic v(xdut.n_xarray/xi15/xi31/net2_xarray/xi15/xi31/mm0_g)=0
.ic v(xdut.n_xarray/xi15/xi31/net4_xarray/xi15/xi31/mm1_g)=0.8
.ic v(xdut.n_xarray/xi15/xi35/net2_xarray/xi15/xi35/mm0_g)=0
.ic v(xdut.n_xarray/xi15/xi35/net4_xarray/xi15/xi35/mm1_g)=0.8
.ic v(xdut.n_xarray/xi15/xi8/net2_xarray/xi15/xi8/mm0_g)=0
.ic v(xdut.n_xarray/xi15/xi8/net4_xarray/xi15/xi8/mm1_g)=0.8
.ic v(xdut.n_xarray/xi15/xi12/net2_xarray/xi15/xi12/mm0_g)=0
.ic v(xdut.n_xarray/xi15/xi12/net4_xarray/xi15/xi12/mm1_g)=0.8
.ic v(xdut.n_xarray/xi15/xi16/net2_xarray/xi15/xi16/mm0_g)=0
.ic v(xdut.n_xarray/xi15/xi16/net4_xarray/xi15/xi16/mm1_g)=0.8
.ic v(xdut.n_xarray/xi15/xi20/net2_xarray/xi15/xi20/mm0_g)=0
.ic v(xdut.n_xarray/xi15/xi20/net4_xarray/xi15/xi20/mm1_g)=0.8
.ic v(xdut.n_xarray/xi15/xi24/net2_xarray/xi15/xi24/mm0_g)=0
.ic v(xdut.n_xarray/xi15/xi24/net4_xarray/xi15/xi24/mm1_g)=0.8
.ic v(xdut.n_xarray/xi15/xi28/net2_xarray/xi15/xi28/mm0_g)=0
.ic v(xdut.n_xarray/xi15/xi28/net4_xarray/xi15/xi28/mm1_g)=0.8
.ic v(xdut.n_xarray/xi15/xi32/net2_xarray/xi15/xi32/mm0_g)=0
.ic v(xdut.n_xarray/xi15/xi32/net4_xarray/xi15/xi32/mm1_g)=0.8
.ic v(xdut.n_xarray/xi15/xi36/net2_xarray/xi15/xi36/mm0_g)=0
.ic v(xdut.n_xarray/xi15/xi36/net4_xarray/xi15/xi36/mm1_g)=0.8
.ic v(xdut.n_xarray/xi14/xi5/net2_xarray/xi14/xi5/mm0_g)=0
.ic v(xdut.n_xarray/xi14/xi5/net4_xarray/xi14/xi5/mm1_g)=0.8
.ic v(xdut.n_xarray/xi14/xi9/net2_xarray/xi14/xi9/mm0_g)=0
.ic v(xdut.n_xarray/xi14/xi9/net4_xarray/xi14/xi9/mm1_g)=0.8
.ic v(xdut.n_xarray/xi14/xi13/net2_xarray/xi14/xi13/mm0_g)=0
.ic v(xdut.n_xarray/xi14/xi13/net4_xarray/xi14/xi13/mm1_g)=0.8
.ic v(xdut.n_xarray/xi14/xi17/net2_xarray/xi14/xi17/mm0_g)=0
.ic v(xdut.n_xarray/xi14/xi17/net4_xarray/xi14/xi17/mm1_g)=0.8
.ic v(xdut.n_xarray/xi14/xi21/net2_xarray/xi14/xi21/mm0_g)=0
.ic v(xdut.n_xarray/xi14/xi21/net4_xarray/xi14/xi21/mm1_g)=0.8
.ic v(xdut.n_xarray/xi14/xi25/net2_xarray/xi14/xi25/mm0_g)=0
.ic v(xdut.n_xarray/xi14/xi25/net4_xarray/xi14/xi25/mm1_g)=0.8
.ic v(xdut.n_xarray/xi14/xi29/net2_xarray/xi14/xi29/mm0_g)=0
.ic v(xdut.n_xarray/xi14/xi29/net4_xarray/xi14/xi29/mm1_g)=0.8
.ic v(xdut.n_xarray/xi14/xi33/net2_xarray/xi14/xi33/mm0_g)=0
.ic v(xdut.n_xarray/xi14/xi33/net4_xarray/xi14/xi33/mm1_g)=0.8
.ic v(xdut.n_xarray/xi14/xi6/net2_xarray/xi14/xi6/mm0_g)=0
.ic v(xdut.n_xarray/xi14/xi6/net4_xarray/xi14/xi6/mm1_g)=0.8
.ic v(xdut.n_xarray/xi14/xi10/net2_xarray/xi14/xi10/mm0_g)=0
.ic v(xdut.n_xarray/xi14/xi10/net4_xarray/xi14/xi10/mm1_g)=0.8
.ic v(xdut.n_xarray/xi14/xi14/net2_xarray/xi14/xi14/mm0_g)=0
.ic v(xdut.n_xarray/xi14/xi14/net4_xarray/xi14/xi14/mm1_g)=0.8
.ic v(xdut.n_xarray/xi14/xi18/net2_xarray/xi14/xi18/mm0_g)=0
.ic v(xdut.n_xarray/xi14/xi18/net4_xarray/xi14/xi18/mm1_g)=0.8
.ic v(xdut.n_xarray/xi14/xi22/net2_xarray/xi14/xi22/mm0_g)=0
.ic v(xdut.n_xarray/xi14/xi22/net4_xarray/xi14/xi22/mm1_g)=0.8
.ic v(xdut.n_xarray/xi14/xi26/net2_xarray/xi14/xi26/mm0_g)=0
.ic v(xdut.n_xarray/xi14/xi26/net4_xarray/xi14/xi26/mm1_g)=0.8
.ic v(xdut.n_xarray/xi14/xi30/net2_xarray/xi14/xi30/mm0_g)=0
.ic v(xdut.n_xarray/xi14/xi30/net4_xarray/xi14/xi30/mm1_g)=0.8
.ic v(xdut.n_xarray/xi14/xi34/net2_xarray/xi14/xi34/mm0_g)=0
.ic v(xdut.n_xarray/xi14/xi34/net4_xarray/xi14/xi34/mm1_g)=0.8
.ic v(xdut.n_xarray/xi14/xi7/net2_xarray/xi14/xi7/mm0_g)=0
.ic v(xdut.n_xarray/xi14/xi7/net4_xarray/xi14/xi7/mm1_g)=0.8
.ic v(xdut.n_xarray/xi14/xi11/net2_xarray/xi14/xi11/mm0_g)=0
.ic v(xdut.n_xarray/xi14/xi11/net4_xarray/xi14/xi11/mm1_g)=0.8
.ic v(xdut.n_xarray/xi14/xi15/net2_xarray/xi14/xi15/mm0_g)=0
.ic v(xdut.n_xarray/xi14/xi15/net4_xarray/xi14/xi15/mm1_g)=0.8
.ic v(xdut.n_xarray/xi14/xi19/net2_xarray/xi14/xi19/mm0_g)=0
.ic v(xdut.n_xarray/xi14/xi19/net4_xarray/xi14/xi19/mm1_g)=0.8
.ic v(xdut.n_xarray/xi14/xi23/net2_xarray/xi14/xi23/mm0_g)=0
.ic v(xdut.n_xarray/xi14/xi23/net4_xarray/xi14/xi23/mm1_g)=0.8
.ic v(xdut.n_xarray/xi14/xi27/net2_xarray/xi14/xi27/mm0_g)=0
.ic v(xdut.n_xarray/xi14/xi27/net4_xarray/xi14/xi27/mm1_g)=0.8
.ic v(xdut.n_xarray/xi14/xi31/net2_xarray/xi14/xi31/mm0_g)=0
.ic v(xdut.n_xarray/xi14/xi31/net4_xarray/xi14/xi31/mm1_g)=0.8
.ic v(xdut.n_xarray/xi14/xi35/net2_xarray/xi14/xi35/mm0_g)=0
.ic v(xdut.n_xarray/xi14/xi35/net4_xarray/xi14/xi35/mm1_g)=0.8
.ic v(xdut.n_xarray/xi14/xi8/net2_xarray/xi14/xi8/mm0_g)=0
.ic v(xdut.n_xarray/xi14/xi8/net4_xarray/xi14/xi8/mm1_g)=0.8
.ic v(xdut.n_xarray/xi14/xi12/net2_xarray/xi14/xi12/mm0_g)=0
.ic v(xdut.n_xarray/xi14/xi12/net4_xarray/xi14/xi12/mm1_g)=0.8
.ic v(xdut.n_xarray/xi14/xi16/net2_xarray/xi14/xi16/mm0_g)=0
.ic v(xdut.n_xarray/xi14/xi16/net4_xarray/xi14/xi16/mm1_g)=0.8
.ic v(xdut.n_xarray/xi14/xi20/net2_xarray/xi14/xi20/mm0_g)=0
.ic v(xdut.n_xarray/xi14/xi20/net4_xarray/xi14/xi20/mm1_g)=0.8
.ic v(xdut.n_xarray/xi14/xi24/net2_xarray/xi14/xi24/mm0_g)=0
.ic v(xdut.n_xarray/xi14/xi24/net4_xarray/xi14/xi24/mm1_g)=0.8
.ic v(xdut.n_xarray/xi14/xi28/net2_xarray/xi14/xi28/mm0_g)=0
.ic v(xdut.n_xarray/xi14/xi28/net4_xarray/xi14/xi28/mm1_g)=0.8
.ic v(xdut.n_xarray/xi14/xi32/net2_xarray/xi14/xi32/mm0_g)=0
.ic v(xdut.n_xarray/xi14/xi32/net4_xarray/xi14/xi32/mm1_g)=0.8
.ic v(xdut.n_xarray/xi14/xi36/net2_xarray/xi14/xi36/mm0_g)=0
.ic v(xdut.n_xarray/xi14/xi36/net4_xarray/xi14/xi36/mm1_g)=0.8
.ic v(xdut.n_xarray/xi13/xi5/net2_xarray/xi13/xi5/mm0_g)=0
.ic v(xdut.n_xarray/xi13/xi5/net4_xarray/xi13/xi5/mm1_g)=0.8
.ic v(xdut.n_xarray/xi13/xi9/net2_xarray/xi13/xi9/mm0_g)=0
.ic v(xdut.n_xarray/xi13/xi9/net4_xarray/xi13/xi9/mm1_g)=0.8
.ic v(xdut.n_xarray/xi13/xi13/net2_xarray/xi13/xi13/mm0_g)=0
.ic v(xdut.n_xarray/xi13/xi13/net4_xarray/xi13/xi13/mm1_g)=0.8
.ic v(xdut.n_xarray/xi13/xi17/net2_xarray/xi13/xi17/mm0_g)=0
.ic v(xdut.n_xarray/xi13/xi17/net4_xarray/xi13/xi17/mm1_g)=0.8
.ic v(xdut.n_xarray/xi13/xi21/net2_xarray/xi13/xi21/mm0_g)=0
.ic v(xdut.n_xarray/xi13/xi21/net4_xarray/xi13/xi21/mm1_g)=0.8
.ic v(xdut.n_xarray/xi13/xi25/net2_xarray/xi13/xi25/mm0_g)=0
.ic v(xdut.n_xarray/xi13/xi25/net4_xarray/xi13/xi25/mm1_g)=0.8
.ic v(xdut.n_xarray/xi13/xi29/net2_xarray/xi13/xi29/mm0_g)=0
.ic v(xdut.n_xarray/xi13/xi29/net4_xarray/xi13/xi29/mm1_g)=0.8
.ic v(xdut.n_xarray/xi13/xi33/net2_xarray/xi13/xi33/mm0_g)=0
.ic v(xdut.n_xarray/xi13/xi33/net4_xarray/xi13/xi33/mm1_g)=0.8
.ic v(xdut.n_xarray/xi13/xi6/net2_xarray/xi13/xi6/mm0_g)=0
.ic v(xdut.n_xarray/xi13/xi6/net4_xarray/xi13/xi6/mm1_g)=0.8
.ic v(xdut.n_xarray/xi13/xi10/net2_xarray/xi13/xi10/mm0_g)=0
.ic v(xdut.n_xarray/xi13/xi10/net4_xarray/xi13/xi10/mm1_g)=0.8
.ic v(xdut.n_xarray/xi13/xi14/net2_xarray/xi13/xi14/mm0_g)=0
.ic v(xdut.n_xarray/xi13/xi14/net4_xarray/xi13/xi14/mm1_g)=0.8
.ic v(xdut.n_xarray/xi13/xi18/net2_xarray/xi13/xi18/mm0_g)=0
.ic v(xdut.n_xarray/xi13/xi18/net4_xarray/xi13/xi18/mm1_g)=0.8
.ic v(xdut.n_xarray/xi13/xi22/net2_xarray/xi13/xi22/mm0_g)=0
.ic v(xdut.n_xarray/xi13/xi22/net4_xarray/xi13/xi22/mm1_g)=0.8
.ic v(xdut.n_xarray/xi13/xi26/net2_xarray/xi13/xi26/mm0_g)=0
.ic v(xdut.n_xarray/xi13/xi26/net4_xarray/xi13/xi26/mm1_g)=0.8
.ic v(xdut.n_xarray/xi13/xi30/net2_xarray/xi13/xi30/mm0_g)=0
.ic v(xdut.n_xarray/xi13/xi30/net4_xarray/xi13/xi30/mm1_g)=0.8
.ic v(xdut.n_xarray/xi13/xi34/net2_xarray/xi13/xi34/mm0_g)=0
.ic v(xdut.n_xarray/xi13/xi34/net4_xarray/xi13/xi34/mm1_g)=0.8
.ic v(xdut.n_xarray/xi13/xi7/net2_xarray/xi13/xi7/mm0_g)=0
.ic v(xdut.n_xarray/xi13/xi7/net4_xarray/xi13/xi7/mm1_g)=0.8
.ic v(xdut.n_xarray/xi13/xi11/net2_xarray/xi13/xi11/mm0_g)=0
.ic v(xdut.n_xarray/xi13/xi11/net4_xarray/xi13/xi11/mm1_g)=0.8
.ic v(xdut.n_xarray/xi13/xi15/net2_xarray/xi13/xi15/mm0_g)=0
.ic v(xdut.n_xarray/xi13/xi15/net4_xarray/xi13/xi15/mm1_g)=0.8
.ic v(xdut.n_xarray/xi13/xi19/net2_xarray/xi13/xi19/mm0_g)=0
.ic v(xdut.n_xarray/xi13/xi19/net4_xarray/xi13/xi19/mm1_g)=0.8
.ic v(xdut.n_xarray/xi13/xi23/net2_xarray/xi13/xi23/mm0_g)=0
.ic v(xdut.n_xarray/xi13/xi23/net4_xarray/xi13/xi23/mm1_g)=0.8
.ic v(xdut.n_xarray/xi13/xi27/net2_xarray/xi13/xi27/mm0_g)=0
.ic v(xdut.n_xarray/xi13/xi27/net4_xarray/xi13/xi27/mm1_g)=0.8
.ic v(xdut.n_xarray/xi13/xi31/net2_xarray/xi13/xi31/mm0_g)=0
.ic v(xdut.n_xarray/xi13/xi31/net4_xarray/xi13/xi31/mm1_g)=0.8
.ic v(xdut.n_xarray/xi13/xi35/net2_xarray/xi13/xi35/mm0_g)=0
.ic v(xdut.n_xarray/xi13/xi35/net4_xarray/xi13/xi35/mm1_g)=0.8
.ic v(xdut.n_xarray/xi13/xi8/net2_xarray/xi13/xi8/mm0_g)=0
.ic v(xdut.n_xarray/xi13/xi8/net4_xarray/xi13/xi8/mm1_g)=0.8
.ic v(xdut.n_xarray/xi13/xi12/net2_xarray/xi13/xi12/mm0_g)=0
.ic v(xdut.n_xarray/xi13/xi12/net4_xarray/xi13/xi12/mm1_g)=0.8
.ic v(xdut.n_xarray/xi13/xi16/net2_xarray/xi13/xi16/mm0_g)=0
.ic v(xdut.n_xarray/xi13/xi16/net4_xarray/xi13/xi16/mm1_g)=0.8
.ic v(xdut.n_xarray/xi13/xi20/net2_xarray/xi13/xi20/mm0_g)=0
.ic v(xdut.n_xarray/xi13/xi20/net4_xarray/xi13/xi20/mm1_g)=0.8
.ic v(xdut.n_xarray/xi13/xi24/net2_xarray/xi13/xi24/mm0_g)=0
.ic v(xdut.n_xarray/xi13/xi24/net4_xarray/xi13/xi24/mm1_g)=0.8
.ic v(xdut.n_xarray/xi13/xi28/net2_xarray/xi13/xi28/mm0_g)=0
.ic v(xdut.n_xarray/xi13/xi28/net4_xarray/xi13/xi28/mm1_g)=0.8
.ic v(xdut.n_xarray/xi13/xi32/net2_xarray/xi13/xi32/mm0_g)=0
.ic v(xdut.n_xarray/xi13/xi32/net4_xarray/xi13/xi32/mm1_g)=0.8
.ic v(xdut.n_xarray/xi13/xi36/net2_xarray/xi13/xi36/mm0_g)=0
.ic v(xdut.n_xarray/xi13/xi36/net4_xarray/xi13/xi36/mm1_g)=0.8
.ic v(xdut.n_xarray/xi12/xi5/net2_xarray/xi12/xi5/mm0_g)=0
.ic v(xdut.n_xarray/xi12/xi5/net4_xarray/xi12/xi5/mm1_g)=0.8
.ic v(xdut.n_xarray/xi12/xi9/net2_xarray/xi12/xi9/mm0_g)=0
.ic v(xdut.n_xarray/xi12/xi9/net4_xarray/xi12/xi9/mm1_g)=0.8
.ic v(xdut.n_xarray/xi12/xi13/net2_xarray/xi12/xi13/mm0_g)=0
.ic v(xdut.n_xarray/xi12/xi13/net4_xarray/xi12/xi13/mm1_g)=0.8
.ic v(xdut.n_xarray/xi12/xi17/net2_xarray/xi12/xi17/mm0_g)=0
.ic v(xdut.n_xarray/xi12/xi17/net4_xarray/xi12/xi17/mm1_g)=0.8
.ic v(xdut.n_xarray/xi12/xi21/net2_xarray/xi12/xi21/mm0_g)=0
.ic v(xdut.n_xarray/xi12/xi21/net4_xarray/xi12/xi21/mm1_g)=0.8
.ic v(xdut.n_xarray/xi12/xi25/net2_xarray/xi12/xi25/mm0_g)=0
.ic v(xdut.n_xarray/xi12/xi25/net4_xarray/xi12/xi25/mm1_g)=0.8
.ic v(xdut.n_xarray/xi12/xi29/net2_xarray/xi12/xi29/mm0_g)=0
.ic v(xdut.n_xarray/xi12/xi29/net4_xarray/xi12/xi29/mm1_g)=0.8
.ic v(xdut.n_xarray/xi12/xi33/net2_xarray/xi12/xi33/mm0_g)=0
.ic v(xdut.n_xarray/xi12/xi33/net4_xarray/xi12/xi33/mm1_g)=0.8
.ic v(xdut.n_xarray/xi12/xi6/net2_xarray/xi12/xi6/mm0_g)=0
.ic v(xdut.n_xarray/xi12/xi6/net4_xarray/xi12/xi6/mm1_g)=0.8
.ic v(xdut.n_xarray/xi12/xi10/net2_xarray/xi12/xi10/mm0_g)=0
.ic v(xdut.n_xarray/xi12/xi10/net4_xarray/xi12/xi10/mm1_g)=0.8
.ic v(xdut.n_xarray/xi12/xi14/net2_xarray/xi12/xi14/mm0_g)=0
.ic v(xdut.n_xarray/xi12/xi14/net4_xarray/xi12/xi14/mm1_g)=0.8
.ic v(xdut.n_xarray/xi12/xi18/net2_xarray/xi12/xi18/mm0_g)=0
.ic v(xdut.n_xarray/xi12/xi18/net4_xarray/xi12/xi18/mm1_g)=0.8
.ic v(xdut.n_xarray/xi12/xi22/net2_xarray/xi12/xi22/mm0_g)=0
.ic v(xdut.n_xarray/xi12/xi22/net4_xarray/xi12/xi22/mm1_g)=0.8
.ic v(xdut.n_xarray/xi12/xi26/net2_xarray/xi12/xi26/mm0_g)=0
.ic v(xdut.n_xarray/xi12/xi26/net4_xarray/xi12/xi26/mm1_g)=0.8
.ic v(xdut.n_xarray/xi12/xi30/net2_xarray/xi12/xi30/mm0_g)=0
.ic v(xdut.n_xarray/xi12/xi30/net4_xarray/xi12/xi30/mm1_g)=0.8
.ic v(xdut.n_xarray/xi12/xi34/net2_xarray/xi12/xi34/mm0_g)=0
.ic v(xdut.n_xarray/xi12/xi34/net4_xarray/xi12/xi34/mm1_g)=0.8
.ic v(xdut.n_xarray/xi12/xi7/net2_xarray/xi12/xi7/mm0_g)=0
.ic v(xdut.n_xarray/xi12/xi7/net4_xarray/xi12/xi7/mm1_g)=0.8
.ic v(xdut.n_xarray/xi12/xi11/net2_xarray/xi12/xi11/mm0_g)=0
.ic v(xdut.n_xarray/xi12/xi11/net4_xarray/xi12/xi11/mm1_g)=0.8
.ic v(xdut.n_xarray/xi12/xi15/net2_xarray/xi12/xi15/mm0_g)=0
.ic v(xdut.n_xarray/xi12/xi15/net4_xarray/xi12/xi15/mm1_g)=0.8
.ic v(xdut.n_xarray/xi12/xi19/net2_xarray/xi12/xi19/mm0_g)=0
.ic v(xdut.n_xarray/xi12/xi19/net4_xarray/xi12/xi19/mm1_g)=0.8
.ic v(xdut.n_xarray/xi12/xi23/net2_xarray/xi12/xi23/mm0_g)=0
.ic v(xdut.n_xarray/xi12/xi23/net4_xarray/xi12/xi23/mm1_g)=0.8
.ic v(xdut.n_xarray/xi12/xi27/net2_xarray/xi12/xi27/mm0_g)=0
.ic v(xdut.n_xarray/xi12/xi27/net4_xarray/xi12/xi27/mm1_g)=0.8
.ic v(xdut.n_xarray/xi12/xi31/net2_xarray/xi12/xi31/mm0_g)=0
.ic v(xdut.n_xarray/xi12/xi31/net4_xarray/xi12/xi31/mm1_g)=0.8
.ic v(xdut.n_xarray/xi12/xi35/net2_xarray/xi12/xi35/mm0_g)=0
.ic v(xdut.n_xarray/xi12/xi35/net4_xarray/xi12/xi35/mm1_g)=0.8
.ic v(xdut.n_xarray/xi12/xi8/net2_xarray/xi12/xi8/mm0_g)=0
.ic v(xdut.n_xarray/xi12/xi8/net4_xarray/xi12/xi8/mm1_g)=0.8
.ic v(xdut.n_xarray/xi12/xi12/net2_xarray/xi12/xi12/mm0_g)=0
.ic v(xdut.n_xarray/xi12/xi12/net4_xarray/xi12/xi12/mm1_g)=0.8
.ic v(xdut.n_xarray/xi12/xi16/net2_xarray/xi12/xi16/mm0_g)=0
.ic v(xdut.n_xarray/xi12/xi16/net4_xarray/xi12/xi16/mm1_g)=0.8
.ic v(xdut.n_xarray/xi12/xi20/net2_xarray/xi12/xi20/mm0_g)=0
.ic v(xdut.n_xarray/xi12/xi20/net4_xarray/xi12/xi20/mm1_g)=0.8
.ic v(xdut.n_xarray/xi12/xi24/net2_xarray/xi12/xi24/mm0_g)=0
.ic v(xdut.n_xarray/xi12/xi24/net4_xarray/xi12/xi24/mm1_g)=0.8
.ic v(xdut.n_xarray/xi12/xi28/net2_xarray/xi12/xi28/mm0_g)=0
.ic v(xdut.n_xarray/xi12/xi28/net4_xarray/xi12/xi28/mm1_g)=0.8
.ic v(xdut.n_xarray/xi12/xi32/net2_xarray/xi12/xi32/mm0_g)=0
.ic v(xdut.n_xarray/xi12/xi32/net4_xarray/xi12/xi32/mm1_g)=0.8
.ic v(xdut.n_xarray/xi12/xi36/net2_xarray/xi12/xi36/mm0_g)=0
.ic v(xdut.n_xarray/xi12/xi36/net4_xarray/xi12/xi36/mm1_g)=0.8
.ic v(xdut.n_xarray/xi11/xi5/net2_xarray/xi11/xi5/mm0_g)=0
.ic v(xdut.n_xarray/xi11/xi5/net4_xarray/xi11/xi5/mm1_g)=0.8
.ic v(xdut.n_xarray/xi11/xi9/net2_xarray/xi11/xi9/mm0_g)=0
.ic v(xdut.n_xarray/xi11/xi9/net4_xarray/xi11/xi9/mm1_g)=0.8
.ic v(xdut.n_xarray/xi11/xi13/net2_xarray/xi11/xi13/mm0_g)=0
.ic v(xdut.n_xarray/xi11/xi13/net4_xarray/xi11/xi13/mm1_g)=0.8
.ic v(xdut.n_xarray/xi11/xi17/net2_xarray/xi11/xi17/mm0_g)=0
.ic v(xdut.n_xarray/xi11/xi17/net4_xarray/xi11/xi17/mm1_g)=0.8
.ic v(xdut.n_xarray/xi11/xi21/net2_xarray/xi11/xi21/mm0_g)=0
.ic v(xdut.n_xarray/xi11/xi21/net4_xarray/xi11/xi21/mm1_g)=0.8
.ic v(xdut.n_xarray/xi11/xi25/net2_xarray/xi11/xi25/mm0_g)=0
.ic v(xdut.n_xarray/xi11/xi25/net4_xarray/xi11/xi25/mm1_g)=0.8
.ic v(xdut.n_xarray/xi11/xi29/net2_xarray/xi11/xi29/mm0_g)=0
.ic v(xdut.n_xarray/xi11/xi29/net4_xarray/xi11/xi29/mm1_g)=0.8
.ic v(xdut.n_xarray/xi11/xi33/net2_xarray/xi11/xi33/mm0_g)=0
.ic v(xdut.n_xarray/xi11/xi33/net4_xarray/xi11/xi33/mm1_g)=0.8
.ic v(xdut.n_xarray/xi11/xi6/net2_xarray/xi11/xi6/mm0_g)=0
.ic v(xdut.n_xarray/xi11/xi6/net4_xarray/xi11/xi6/mm1_g)=0.8
.ic v(xdut.n_xarray/xi11/xi10/net2_xarray/xi11/xi10/mm0_g)=0
.ic v(xdut.n_xarray/xi11/xi10/net4_xarray/xi11/xi10/mm1_g)=0.8
.ic v(xdut.n_xarray/xi11/xi14/net2_xarray/xi11/xi14/mm0_g)=0
.ic v(xdut.n_xarray/xi11/xi14/net4_xarray/xi11/xi14/mm1_g)=0.8
.ic v(xdut.n_xarray/xi11/xi18/net2_xarray/xi11/xi18/mm0_g)=0
.ic v(xdut.n_xarray/xi11/xi18/net4_xarray/xi11/xi18/mm1_g)=0.8
.ic v(xdut.n_xarray/xi11/xi22/net2_xarray/xi11/xi22/mm0_g)=0
.ic v(xdut.n_xarray/xi11/xi22/net4_xarray/xi11/xi22/mm1_g)=0.8
.ic v(xdut.n_xarray/xi11/xi26/net2_xarray/xi11/xi26/mm0_g)=0
.ic v(xdut.n_xarray/xi11/xi26/net4_xarray/xi11/xi26/mm1_g)=0.8
.ic v(xdut.n_xarray/xi11/xi30/net2_xarray/xi11/xi30/mm0_g)=0
.ic v(xdut.n_xarray/xi11/xi30/net4_xarray/xi11/xi30/mm1_g)=0.8
.ic v(xdut.n_xarray/xi11/xi34/net2_xarray/xi11/xi34/mm0_g)=0
.ic v(xdut.n_xarray/xi11/xi34/net4_xarray/xi11/xi34/mm1_g)=0.8
.ic v(xdut.n_xarray/xi11/xi7/net2_xarray/xi11/xi7/mm0_g)=0
.ic v(xdut.n_xarray/xi11/xi7/net4_xarray/xi11/xi7/mm1_g)=0.8
.ic v(xdut.n_xarray/xi11/xi11/net2_xarray/xi11/xi11/mm0_g)=0
.ic v(xdut.n_xarray/xi11/xi11/net4_xarray/xi11/xi11/mm1_g)=0.8
.ic v(xdut.n_xarray/xi11/xi15/net2_xarray/xi11/xi15/mm0_g)=0
.ic v(xdut.n_xarray/xi11/xi15/net4_xarray/xi11/xi15/mm1_g)=0.8
.ic v(xdut.n_xarray/xi11/xi19/net2_xarray/xi11/xi19/mm0_g)=0
.ic v(xdut.n_xarray/xi11/xi19/net4_xarray/xi11/xi19/mm1_g)=0.8
.ic v(xdut.n_xarray/xi11/xi23/net2_xarray/xi11/xi23/mm0_g)=0
.ic v(xdut.n_xarray/xi11/xi23/net4_xarray/xi11/xi23/mm1_g)=0.8
.ic v(xdut.n_xarray/xi11/xi27/net2_xarray/xi11/xi27/mm0_g)=0
.ic v(xdut.n_xarray/xi11/xi27/net4_xarray/xi11/xi27/mm1_g)=0.8
.ic v(xdut.n_xarray/xi11/xi31/net2_xarray/xi11/xi31/mm0_g)=0
.ic v(xdut.n_xarray/xi11/xi31/net4_xarray/xi11/xi31/mm1_g)=0.8
.ic v(xdut.n_xarray/xi11/xi35/net2_xarray/xi11/xi35/mm0_g)=0
.ic v(xdut.n_xarray/xi11/xi35/net4_xarray/xi11/xi35/mm1_g)=0.8
.ic v(xdut.n_xarray/xi11/xi8/net2_xarray/xi11/xi8/mm0_g)=0
.ic v(xdut.n_xarray/xi11/xi8/net4_xarray/xi11/xi8/mm1_g)=0.8
.ic v(xdut.n_xarray/xi11/xi12/net2_xarray/xi11/xi12/mm0_g)=0
.ic v(xdut.n_xarray/xi11/xi12/net4_xarray/xi11/xi12/mm1_g)=0.8
.ic v(xdut.n_xarray/xi11/xi16/net2_xarray/xi11/xi16/mm0_g)=0
.ic v(xdut.n_xarray/xi11/xi16/net4_xarray/xi11/xi16/mm1_g)=0.8
.ic v(xdut.n_xarray/xi11/xi20/net2_xarray/xi11/xi20/mm0_g)=0
.ic v(xdut.n_xarray/xi11/xi20/net4_xarray/xi11/xi20/mm1_g)=0.8
.ic v(xdut.n_xarray/xi11/xi24/net2_xarray/xi11/xi24/mm0_g)=0
.ic v(xdut.n_xarray/xi11/xi24/net4_xarray/xi11/xi24/mm1_g)=0.8
.ic v(xdut.n_xarray/xi11/xi28/net2_xarray/xi11/xi28/mm0_g)=0
.ic v(xdut.n_xarray/xi11/xi28/net4_xarray/xi11/xi28/mm1_g)=0.8
.ic v(xdut.n_xarray/xi11/xi32/net2_xarray/xi11/xi32/mm0_g)=0
.ic v(xdut.n_xarray/xi11/xi32/net4_xarray/xi11/xi32/mm1_g)=0.8
.ic v(xdut.n_xarray/xi11/xi36/net2_xarray/xi11/xi36/mm0_g)=0
.ic v(xdut.n_xarray/xi11/xi36/net4_xarray/xi11/xi36/mm1_g)=0.8
.ic v(xdut.n_xarray/xi10/xi5/net2_xarray/xi10/xi5/mm0_g)=0
.ic v(xdut.n_xarray/xi10/xi5/net4_xarray/xi10/xi5/mm1_g)=0.8
.ic v(xdut.n_xarray/xi10/xi9/net2_xarray/xi10/xi9/mm0_g)=0
.ic v(xdut.n_xarray/xi10/xi9/net4_xarray/xi10/xi9/mm1_g)=0.8
.ic v(xdut.n_xarray/xi10/xi13/net2_xarray/xi10/xi13/mm0_g)=0
.ic v(xdut.n_xarray/xi10/xi13/net4_xarray/xi10/xi13/mm1_g)=0.8
.ic v(xdut.n_xarray/xi10/xi17/net2_xarray/xi10/xi17/mm0_g)=0
.ic v(xdut.n_xarray/xi10/xi17/net4_xarray/xi10/xi17/mm1_g)=0.8
.ic v(xdut.n_xarray/xi10/xi21/net2_xarray/xi10/xi21/mm0_g)=0
.ic v(xdut.n_xarray/xi10/xi21/net4_xarray/xi10/xi21/mm1_g)=0.8
.ic v(xdut.n_xarray/xi10/xi25/net2_xarray/xi10/xi25/mm0_g)=0
.ic v(xdut.n_xarray/xi10/xi25/net4_xarray/xi10/xi25/mm1_g)=0.8
.ic v(xdut.n_xarray/xi10/xi29/net2_xarray/xi10/xi29/mm0_g)=0
.ic v(xdut.n_xarray/xi10/xi29/net4_xarray/xi10/xi29/mm1_g)=0.8
.ic v(xdut.n_xarray/xi10/xi33/net2_xarray/xi10/xi33/mm0_g)=0
.ic v(xdut.n_xarray/xi10/xi33/net4_xarray/xi10/xi33/mm1_g)=0.8
.ic v(xdut.n_xarray/xi10/xi6/net2_xarray/xi10/xi6/mm0_g)=0
.ic v(xdut.n_xarray/xi10/xi6/net4_xarray/xi10/xi6/mm1_g)=0.8
.ic v(xdut.n_xarray/xi10/xi10/net2_xarray/xi10/xi10/mm0_g)=0
.ic v(xdut.n_xarray/xi10/xi10/net4_xarray/xi10/xi10/mm1_g)=0.8
.ic v(xdut.n_xarray/xi10/xi14/net2_xarray/xi10/xi14/mm0_g)=0
.ic v(xdut.n_xarray/xi10/xi14/net4_xarray/xi10/xi14/mm1_g)=0.8
.ic v(xdut.n_xarray/xi10/xi18/net2_xarray/xi10/xi18/mm0_g)=0
.ic v(xdut.n_xarray/xi10/xi18/net4_xarray/xi10/xi18/mm1_g)=0.8
.ic v(xdut.n_xarray/xi10/xi22/net2_xarray/xi10/xi22/mm0_g)=0
.ic v(xdut.n_xarray/xi10/xi22/net4_xarray/xi10/xi22/mm1_g)=0.8
.ic v(xdut.n_xarray/xi10/xi26/net2_xarray/xi10/xi26/mm0_g)=0
.ic v(xdut.n_xarray/xi10/xi26/net4_xarray/xi10/xi26/mm1_g)=0.8
.ic v(xdut.n_xarray/xi10/xi30/net2_xarray/xi10/xi30/mm0_g)=0
.ic v(xdut.n_xarray/xi10/xi30/net4_xarray/xi10/xi30/mm1_g)=0.8
.ic v(xdut.n_xarray/xi10/xi34/net2_xarray/xi10/xi34/mm0_g)=0
.ic v(xdut.n_xarray/xi10/xi34/net4_xarray/xi10/xi34/mm1_g)=0.8
.ic v(xdut.n_xarray/xi10/xi7/net2_xarray/xi10/xi7/mm0_g)=0
.ic v(xdut.n_xarray/xi10/xi7/net4_xarray/xi10/xi7/mm1_g)=0.8
.ic v(xdut.n_xarray/xi10/xi11/net2_xarray/xi10/xi11/mm0_g)=0
.ic v(xdut.n_xarray/xi10/xi11/net4_xarray/xi10/xi11/mm1_g)=0.8
.ic v(xdut.n_xarray/xi10/xi15/net2_xarray/xi10/xi15/mm0_g)=0
.ic v(xdut.n_xarray/xi10/xi15/net4_xarray/xi10/xi15/mm1_g)=0.8
.ic v(xdut.n_xarray/xi10/xi19/net2_xarray/xi10/xi19/mm0_g)=0
.ic v(xdut.n_xarray/xi10/xi19/net4_xarray/xi10/xi19/mm1_g)=0.8
.ic v(xdut.n_xarray/xi10/xi23/net2_xarray/xi10/xi23/mm0_g)=0
.ic v(xdut.n_xarray/xi10/xi23/net4_xarray/xi10/xi23/mm1_g)=0.8
.ic v(xdut.n_xarray/xi10/xi27/net2_xarray/xi10/xi27/mm0_g)=0
.ic v(xdut.n_xarray/xi10/xi27/net4_xarray/xi10/xi27/mm1_g)=0.8
.ic v(xdut.n_xarray/xi10/xi31/net2_xarray/xi10/xi31/mm0_g)=0
.ic v(xdut.n_xarray/xi10/xi31/net4_xarray/xi10/xi31/mm1_g)=0.8
.ic v(xdut.n_xarray/xi10/xi35/net2_xarray/xi10/xi35/mm0_g)=0
.ic v(xdut.n_xarray/xi10/xi35/net4_xarray/xi10/xi35/mm1_g)=0.8
.ic v(xdut.n_xarray/xi10/xi8/net2_xarray/xi10/xi8/mm0_g)=0
.ic v(xdut.n_xarray/xi10/xi8/net4_xarray/xi10/xi8/mm1_g)=0.8
.ic v(xdut.n_xarray/xi10/xi12/net2_xarray/xi10/xi12/mm0_g)=0
.ic v(xdut.n_xarray/xi10/xi12/net4_xarray/xi10/xi12/mm1_g)=0.8
.ic v(xdut.n_xarray/xi10/xi16/net2_xarray/xi10/xi16/mm0_g)=0
.ic v(xdut.n_xarray/xi10/xi16/net4_xarray/xi10/xi16/mm1_g)=0.8
.ic v(xdut.n_xarray/xi10/xi20/net2_xarray/xi10/xi20/mm0_g)=0
.ic v(xdut.n_xarray/xi10/xi20/net4_xarray/xi10/xi20/mm1_g)=0.8
.ic v(xdut.n_xarray/xi10/xi24/net2_xarray/xi10/xi24/mm0_g)=0
.ic v(xdut.n_xarray/xi10/xi24/net4_xarray/xi10/xi24/mm1_g)=0.8
.ic v(xdut.n_xarray/xi10/xi28/net2_xarray/xi10/xi28/mm0_g)=0
.ic v(xdut.n_xarray/xi10/xi28/net4_xarray/xi10/xi28/mm1_g)=0.8
.ic v(xdut.n_xarray/xi10/xi32/net2_xarray/xi10/xi32/mm0_g)=0
.ic v(xdut.n_xarray/xi10/xi32/net4_xarray/xi10/xi32/mm1_g)=0.8
.ic v(xdut.n_xarray/xi10/xi36/net2_xarray/xi10/xi36/mm0_g)=0
.ic v(xdut.n_xarray/xi10/xi36/net4_xarray/xi10/xi36/mm1_g)=0.8
.ic v(xdut.n_xarray/xi9/xi5/net2_xarray/xi9/xi5/mm0_g)=0
.ic v(xdut.n_xarray/xi9/xi5/net4_xarray/xi9/xi5/mm1_g)=0.8
.ic v(xdut.n_xarray/xi9/xi9/net2_xarray/xi9/xi9/mm0_g)=0
.ic v(xdut.n_xarray/xi9/xi9/net4_xarray/xi9/xi9/mm1_g)=0.8
.ic v(xdut.n_xarray/xi9/xi13/net2_xarray/xi9/xi13/mm0_g)=0
.ic v(xdut.n_xarray/xi9/xi13/net4_xarray/xi9/xi13/mm1_g)=0.8
.ic v(xdut.n_xarray/xi9/xi17/net2_xarray/xi9/xi17/mm0_g)=0
.ic v(xdut.n_xarray/xi9/xi17/net4_xarray/xi9/xi17/mm1_g)=0.8
.ic v(xdut.n_xarray/xi9/xi21/net2_xarray/xi9/xi21/mm0_g)=0
.ic v(xdut.n_xarray/xi9/xi21/net4_xarray/xi9/xi21/mm1_g)=0.8
.ic v(xdut.n_xarray/xi9/xi25/net2_xarray/xi9/xi25/mm0_g)=0
.ic v(xdut.n_xarray/xi9/xi25/net4_xarray/xi9/xi25/mm1_g)=0.8
.ic v(xdut.n_xarray/xi9/xi29/net2_xarray/xi9/xi29/mm0_g)=0
.ic v(xdut.n_xarray/xi9/xi29/net4_xarray/xi9/xi29/mm1_g)=0.8
.ic v(xdut.n_xarray/xi9/xi33/net2_xarray/xi9/xi33/mm0_g)=0
.ic v(xdut.n_xarray/xi9/xi33/net4_xarray/xi9/xi33/mm1_g)=0.8
.ic v(xdut.n_xarray/xi9/xi6/net2_xarray/xi9/xi6/mm0_g)=0
.ic v(xdut.n_xarray/xi9/xi6/net4_xarray/xi9/xi6/mm1_g)=0.8
.ic v(xdut.n_xarray/xi9/xi10/net2_xarray/xi9/xi10/mm0_g)=0
.ic v(xdut.n_xarray/xi9/xi10/net4_xarray/xi9/xi10/mm1_g)=0.8
.ic v(xdut.n_xarray/xi9/xi14/net2_xarray/xi9/xi14/mm0_g)=0
.ic v(xdut.n_xarray/xi9/xi14/net4_xarray/xi9/xi14/mm1_g)=0.8
.ic v(xdut.n_xarray/xi9/xi18/net2_xarray/xi9/xi18/mm0_g)=0
.ic v(xdut.n_xarray/xi9/xi18/net4_xarray/xi9/xi18/mm1_g)=0.8
.ic v(xdut.n_xarray/xi9/xi22/net2_xarray/xi9/xi22/mm0_g)=0
.ic v(xdut.n_xarray/xi9/xi22/net4_xarray/xi9/xi22/mm1_g)=0.8
.ic v(xdut.n_xarray/xi9/xi26/net2_xarray/xi9/xi26/mm0_g)=0
.ic v(xdut.n_xarray/xi9/xi26/net4_xarray/xi9/xi26/mm1_g)=0.8
.ic v(xdut.n_xarray/xi9/xi30/net2_xarray/xi9/xi30/mm0_g)=0
.ic v(xdut.n_xarray/xi9/xi30/net4_xarray/xi9/xi30/mm1_g)=0.8
.ic v(xdut.n_xarray/xi9/xi34/net2_xarray/xi9/xi34/mm0_g)=0
.ic v(xdut.n_xarray/xi9/xi34/net4_xarray/xi9/xi34/mm1_g)=0.8
.ic v(xdut.n_xarray/xi9/xi7/net2_xarray/xi9/xi7/mm0_g)=0
.ic v(xdut.n_xarray/xi9/xi7/net4_xarray/xi9/xi7/mm1_g)=0.8
.ic v(xdut.n_xarray/xi9/xi11/net2_xarray/xi9/xi11/mm0_g)=0
.ic v(xdut.n_xarray/xi9/xi11/net4_xarray/xi9/xi11/mm1_g)=0.8
.ic v(xdut.n_xarray/xi9/xi15/net2_xarray/xi9/xi15/mm0_g)=0
.ic v(xdut.n_xarray/xi9/xi15/net4_xarray/xi9/xi15/mm1_g)=0.8
.ic v(xdut.n_xarray/xi9/xi19/net2_xarray/xi9/xi19/mm0_g)=0
.ic v(xdut.n_xarray/xi9/xi19/net4_xarray/xi9/xi19/mm1_g)=0.8
.ic v(xdut.n_xarray/xi9/xi23/net2_xarray/xi9/xi23/mm0_g)=0
.ic v(xdut.n_xarray/xi9/xi23/net4_xarray/xi9/xi23/mm1_g)=0.8
.ic v(xdut.n_xarray/xi9/xi27/net2_xarray/xi9/xi27/mm0_g)=0
.ic v(xdut.n_xarray/xi9/xi27/net4_xarray/xi9/xi27/mm1_g)=0.8
.ic v(xdut.n_xarray/xi9/xi31/net2_xarray/xi9/xi31/mm0_g)=0
.ic v(xdut.n_xarray/xi9/xi31/net4_xarray/xi9/xi31/mm1_g)=0.8
.ic v(xdut.n_xarray/xi9/xi35/net2_xarray/xi9/xi35/mm0_g)=0
.ic v(xdut.n_xarray/xi9/xi35/net4_xarray/xi9/xi35/mm1_g)=0.8
.ic v(xdut.n_xarray/xi9/xi8/net2_xarray/xi9/xi8/mm0_g)=0
.ic v(xdut.n_xarray/xi9/xi8/net4_xarray/xi9/xi8/mm1_g)=0.8
.ic v(xdut.n_xarray/xi9/xi12/net2_xarray/xi9/xi12/mm0_g)=0
.ic v(xdut.n_xarray/xi9/xi12/net4_xarray/xi9/xi12/mm1_g)=0.8
.ic v(xdut.n_xarray/xi9/xi16/net2_xarray/xi9/xi16/mm0_g)=0
.ic v(xdut.n_xarray/xi9/xi16/net4_xarray/xi9/xi16/mm1_g)=0.8
.ic v(xdut.n_xarray/xi9/xi20/net2_xarray/xi9/xi20/mm0_g)=0
.ic v(xdut.n_xarray/xi9/xi20/net4_xarray/xi9/xi20/mm1_g)=0.8
.ic v(xdut.n_xarray/xi9/xi24/net2_xarray/xi9/xi24/mm0_g)=0
.ic v(xdut.n_xarray/xi9/xi24/net4_xarray/xi9/xi24/mm1_g)=0.8
.ic v(xdut.n_xarray/xi9/xi28/net2_xarray/xi9/xi28/mm0_g)=0
.ic v(xdut.n_xarray/xi9/xi28/net4_xarray/xi9/xi28/mm1_g)=0.8
.ic v(xdut.n_xarray/xi9/xi32/net2_xarray/xi9/xi32/mm0_g)=0
.ic v(xdut.n_xarray/xi9/xi32/net4_xarray/xi9/xi32/mm1_g)=0.8
.ic v(xdut.n_xarray/xi9/xi36/net2_xarray/xi9/xi36/mm0_g)=0
.ic v(xdut.n_xarray/xi9/xi36/net4_xarray/xi9/xi36/mm1_g)=0.8
.ic v(xdut.n_xarray/xi8/xi5/net2_xarray/xi8/xi5/mm0_g)=0
.ic v(xdut.n_xarray/xi8/xi5/net4_xarray/xi8/xi5/mm1_g)=0.8
.ic v(xdut.n_xarray/xi8/xi9/net2_xarray/xi8/xi9/mm0_g)=0
.ic v(xdut.n_xarray/xi8/xi9/net4_xarray/xi8/xi9/mm1_g)=0.8
.ic v(xdut.n_xarray/xi8/xi13/net2_xarray/xi8/xi13/mm0_g)=0
.ic v(xdut.n_xarray/xi8/xi13/net4_xarray/xi8/xi13/mm1_g)=0.8
.ic v(xdut.n_xarray/xi8/xi17/net2_xarray/xi8/xi17/mm0_g)=0
.ic v(xdut.n_xarray/xi8/xi17/net4_xarray/xi8/xi17/mm1_g)=0.8
.ic v(xdut.n_xarray/xi8/xi21/net2_xarray/xi8/xi21/mm0_g)=0
.ic v(xdut.n_xarray/xi8/xi21/net4_xarray/xi8/xi21/mm1_g)=0.8
.ic v(xdut.n_xarray/xi8/xi25/net2_xarray/xi8/xi25/mm0_g)=0
.ic v(xdut.n_xarray/xi8/xi25/net4_xarray/xi8/xi25/mm1_g)=0.8
.ic v(xdut.n_xarray/xi8/xi29/net2_xarray/xi8/xi29/mm0_g)=0
.ic v(xdut.n_xarray/xi8/xi29/net4_xarray/xi8/xi29/mm1_g)=0.8
.ic v(xdut.n_xarray/xi8/xi33/net2_xarray/xi8/xi33/mm0_g)=0
.ic v(xdut.n_xarray/xi8/xi33/net4_xarray/xi8/xi33/mm1_g)=0.8
.ic v(xdut.n_xarray/xi8/xi6/net2_xarray/xi8/xi6/mm0_g)=0
.ic v(xdut.n_xarray/xi8/xi6/net4_xarray/xi8/xi6/mm1_g)=0.8
.ic v(xdut.n_xarray/xi8/xi10/net2_xarray/xi8/xi10/mm0_g)=0
.ic v(xdut.n_xarray/xi8/xi10/net4_xarray/xi8/xi10/mm1_g)=0.8
.ic v(xdut.n_xarray/xi8/xi14/net2_xarray/xi8/xi14/mm0_g)=0
.ic v(xdut.n_xarray/xi8/xi14/net4_xarray/xi8/xi14/mm1_g)=0.8
.ic v(xdut.n_xarray/xi8/xi18/net2_xarray/xi8/xi18/mm0_g)=0
.ic v(xdut.n_xarray/xi8/xi18/net4_xarray/xi8/xi18/mm1_g)=0.8
.ic v(xdut.n_xarray/xi8/xi22/net2_xarray/xi8/xi22/mm0_g)=0
.ic v(xdut.n_xarray/xi8/xi22/net4_xarray/xi8/xi22/mm1_g)=0.8
.ic v(xdut.n_xarray/xi8/xi26/net2_xarray/xi8/xi26/mm0_g)=0
.ic v(xdut.n_xarray/xi8/xi26/net4_xarray/xi8/xi26/mm1_g)=0.8
.ic v(xdut.n_xarray/xi8/xi30/net2_xarray/xi8/xi30/mm0_g)=0
.ic v(xdut.n_xarray/xi8/xi30/net4_xarray/xi8/xi30/mm1_g)=0.8
.ic v(xdut.n_xarray/xi8/xi34/net2_xarray/xi8/xi34/mm0_g)=0
.ic v(xdut.n_xarray/xi8/xi34/net4_xarray/xi8/xi34/mm1_g)=0.8
.ic v(xdut.n_xarray/xi8/xi7/net2_xarray/xi8/xi7/mm0_g)=0
.ic v(xdut.n_xarray/xi8/xi7/net4_xarray/xi8/xi7/mm1_g)=0.8
.ic v(xdut.n_xarray/xi8/xi11/net2_xarray/xi8/xi11/mm0_g)=0
.ic v(xdut.n_xarray/xi8/xi11/net4_xarray/xi8/xi11/mm1_g)=0.8
.ic v(xdut.n_xarray/xi8/xi15/net2_xarray/xi8/xi15/mm0_g)=0
.ic v(xdut.n_xarray/xi8/xi15/net4_xarray/xi8/xi15/mm1_g)=0.8
.ic v(xdut.n_xarray/xi8/xi19/net2_xarray/xi8/xi19/mm0_g)=0
.ic v(xdut.n_xarray/xi8/xi19/net4_xarray/xi8/xi19/mm1_g)=0.8
.ic v(xdut.n_xarray/xi8/xi23/net2_xarray/xi8/xi23/mm0_g)=0
.ic v(xdut.n_xarray/xi8/xi23/net4_xarray/xi8/xi23/mm1_g)=0.8
.ic v(xdut.n_xarray/xi8/xi27/net2_xarray/xi8/xi27/mm0_g)=0
.ic v(xdut.n_xarray/xi8/xi27/net4_xarray/xi8/xi27/mm1_g)=0.8
.ic v(xdut.n_xarray/xi8/xi31/net2_xarray/xi8/xi31/mm0_g)=0
.ic v(xdut.n_xarray/xi8/xi31/net4_xarray/xi8/xi31/mm1_g)=0.8
.ic v(xdut.n_xarray/xi8/xi35/net2_xarray/xi8/xi35/mm0_g)=0
.ic v(xdut.n_xarray/xi8/xi35/net4_xarray/xi8/xi35/mm1_g)=0.8
.ic v(xdut.n_xarray/xi8/xi8/net2_xarray/xi8/xi8/mm0_g)=0
.ic v(xdut.n_xarray/xi8/xi8/net4_xarray/xi8/xi8/mm1_g)=0.8
.ic v(xdut.n_xarray/xi8/xi12/net2_xarray/xi8/xi12/mm0_g)=0
.ic v(xdut.n_xarray/xi8/xi12/net4_xarray/xi8/xi12/mm1_g)=0.8
.ic v(xdut.n_xarray/xi8/xi16/net2_xarray/xi8/xi16/mm0_g)=0
.ic v(xdut.n_xarray/xi8/xi16/net4_xarray/xi8/xi16/mm1_g)=0.8
.ic v(xdut.n_xarray/xi8/xi20/net2_xarray/xi8/xi20/mm0_g)=0
.ic v(xdut.n_xarray/xi8/xi20/net4_xarray/xi8/xi20/mm1_g)=0.8
.ic v(xdut.n_xarray/xi8/xi24/net2_xarray/xi8/xi24/mm0_g)=0
.ic v(xdut.n_xarray/xi8/xi24/net4_xarray/xi8/xi24/mm1_g)=0.8
.ic v(xdut.n_xarray/xi8/xi28/net2_xarray/xi8/xi28/mm0_g)=0
.ic v(xdut.n_xarray/xi8/xi28/net4_xarray/xi8/xi28/mm1_g)=0.8
.ic v(xdut.n_xarray/xi8/xi32/net2_xarray/xi8/xi32/mm0_g)=0
.ic v(xdut.n_xarray/xi8/xi32/net4_xarray/xi8/xi32/mm1_g)=0.8
.ic v(xdut.n_xarray/xi8/xi36/net2_xarray/xi8/xi36/mm0_g)=0
.ic v(xdut.n_xarray/xi8/xi36/net4_xarray/xi8/xi36/mm1_g)=0.8
.ic v(xdut.n_xarray/xi7/xi5/net2_xarray/xi7/xi5/mm0_g)=0
.ic v(xdut.n_xarray/xi7/xi5/net4_xarray/xi7/xi5/mm1_g)=0.8
.ic v(xdut.n_xarray/xi7/xi9/net2_xarray/xi7/xi9/mm0_g)=0
.ic v(xdut.n_xarray/xi7/xi9/net4_xarray/xi7/xi9/mm1_g)=0.8
.ic v(xdut.n_xarray/xi7/xi13/net2_xarray/xi7/xi13/mm0_g)=0
.ic v(xdut.n_xarray/xi7/xi13/net4_xarray/xi7/xi13/mm1_g)=0.8
.ic v(xdut.n_xarray/xi7/xi17/net2_xarray/xi7/xi17/mm0_g)=0
.ic v(xdut.n_xarray/xi7/xi17/net4_xarray/xi7/xi17/mm1_g)=0.8
.ic v(xdut.n_xarray/xi7/xi21/net2_xarray/xi7/xi21/mm0_g)=0
.ic v(xdut.n_xarray/xi7/xi21/net4_xarray/xi7/xi21/mm1_g)=0.8
.ic v(xdut.n_xarray/xi7/xi25/net2_xarray/xi7/xi25/mm0_g)=0
.ic v(xdut.n_xarray/xi7/xi25/net4_xarray/xi7/xi25/mm1_g)=0.8
.ic v(xdut.n_xarray/xi7/xi29/net2_xarray/xi7/xi29/mm0_g)=0
.ic v(xdut.n_xarray/xi7/xi29/net4_xarray/xi7/xi29/mm1_g)=0.8
.ic v(xdut.n_xarray/xi7/xi33/net2_xarray/xi7/xi33/mm0_g)=0
.ic v(xdut.n_xarray/xi7/xi33/net4_xarray/xi7/xi33/mm1_g)=0.8
.ic v(xdut.n_xarray/xi7/xi6/net2_xarray/xi7/xi6/mm0_g)=0
.ic v(xdut.n_xarray/xi7/xi6/net4_xarray/xi7/xi6/mm1_g)=0.8
.ic v(xdut.n_xarray/xi7/xi10/net2_xarray/xi7/xi10/mm0_g)=0
.ic v(xdut.n_xarray/xi7/xi10/net4_xarray/xi7/xi10/mm1_g)=0.8
.ic v(xdut.n_xarray/xi7/xi14/net2_xarray/xi7/xi14/mm0_g)=0
.ic v(xdut.n_xarray/xi7/xi14/net4_xarray/xi7/xi14/mm1_g)=0.8
.ic v(xdut.n_xarray/xi7/xi18/net2_xarray/xi7/xi18/mm0_g)=0
.ic v(xdut.n_xarray/xi7/xi18/net4_xarray/xi7/xi18/mm1_g)=0.8
.ic v(xdut.n_xarray/xi7/xi22/net2_xarray/xi7/xi22/mm0_g)=0
.ic v(xdut.n_xarray/xi7/xi22/net4_xarray/xi7/xi22/mm1_g)=0.8
.ic v(xdut.n_xarray/xi7/xi26/net2_xarray/xi7/xi26/mm0_g)=0
.ic v(xdut.n_xarray/xi7/xi26/net4_xarray/xi7/xi26/mm1_g)=0.8
.ic v(xdut.n_xarray/xi7/xi30/net2_xarray/xi7/xi30/mm0_g)=0
.ic v(xdut.n_xarray/xi7/xi30/net4_xarray/xi7/xi30/mm1_g)=0.8
.ic v(xdut.n_xarray/xi7/xi34/net2_xarray/xi7/xi34/mm0_g)=0
.ic v(xdut.n_xarray/xi7/xi34/net4_xarray/xi7/xi34/mm1_g)=0.8
.ic v(xdut.n_xarray/xi7/xi7/net2_xarray/xi7/xi7/mm0_g)=0
.ic v(xdut.n_xarray/xi7/xi7/net4_xarray/xi7/xi7/mm1_g)=0.8
.ic v(xdut.n_xarray/xi7/xi11/net2_xarray/xi7/xi11/mm0_g)=0
.ic v(xdut.n_xarray/xi7/xi11/net4_xarray/xi7/xi11/mm1_g)=0.8
.ic v(xdut.n_xarray/xi7/xi15/net2_xarray/xi7/xi15/mm0_g)=0
.ic v(xdut.n_xarray/xi7/xi15/net4_xarray/xi7/xi15/mm1_g)=0.8
.ic v(xdut.n_xarray/xi7/xi19/net2_xarray/xi7/xi19/mm0_g)=0
.ic v(xdut.n_xarray/xi7/xi19/net4_xarray/xi7/xi19/mm1_g)=0.8
.ic v(xdut.n_xarray/xi7/xi23/net2_xarray/xi7/xi23/mm0_g)=0
.ic v(xdut.n_xarray/xi7/xi23/net4_xarray/xi7/xi23/mm1_g)=0.8
.ic v(xdut.n_xarray/xi7/xi27/net2_xarray/xi7/xi27/mm0_g)=0
.ic v(xdut.n_xarray/xi7/xi27/net4_xarray/xi7/xi27/mm1_g)=0.8
.ic v(xdut.n_xarray/xi7/xi31/net2_xarray/xi7/xi31/mm0_g)=0
.ic v(xdut.n_xarray/xi7/xi31/net4_xarray/xi7/xi31/mm1_g)=0.8
.ic v(xdut.n_xarray/xi7/xi35/net2_xarray/xi7/xi35/mm0_g)=0
.ic v(xdut.n_xarray/xi7/xi35/net4_xarray/xi7/xi35/mm1_g)=0.8
.ic v(xdut.n_xarray/xi7/xi8/net2_xarray/xi7/xi8/mm0_g)=0
.ic v(xdut.n_xarray/xi7/xi8/net4_xarray/xi7/xi8/mm1_g)=0.8
.ic v(xdut.n_xarray/xi7/xi12/net2_xarray/xi7/xi12/mm0_g)=0
.ic v(xdut.n_xarray/xi7/xi12/net4_xarray/xi7/xi12/mm1_g)=0.8
.ic v(xdut.n_xarray/xi7/xi16/net2_xarray/xi7/xi16/mm0_g)=0
.ic v(xdut.n_xarray/xi7/xi16/net4_xarray/xi7/xi16/mm1_g)=0.8
.ic v(xdut.n_xarray/xi7/xi20/net2_xarray/xi7/xi20/mm0_g)=0
.ic v(xdut.n_xarray/xi7/xi20/net4_xarray/xi7/xi20/mm1_g)=0.8
.ic v(xdut.n_xarray/xi7/xi24/net2_xarray/xi7/xi24/mm0_g)=0
.ic v(xdut.n_xarray/xi7/xi24/net4_xarray/xi7/xi24/mm1_g)=0.8
.ic v(xdut.n_xarray/xi7/xi28/net2_xarray/xi7/xi28/mm0_g)=0
.ic v(xdut.n_xarray/xi7/xi28/net4_xarray/xi7/xi28/mm1_g)=0.8
.ic v(xdut.n_xarray/xi7/xi32/net2_xarray/xi7/xi32/mm0_g)=0
.ic v(xdut.n_xarray/xi7/xi32/net4_xarray/xi7/xi32/mm1_g)=0.8
.ic v(xdut.n_xarray/xi7/xi36/net2_xarray/xi7/xi36/mm0_g)=0
.ic v(xdut.n_xarray/xi7/xi36/net4_xarray/xi7/xi36/mm1_g)=0.8
.ic v(xdut.n_xarray/xi6/xi5/net2_xarray/xi6/xi5/mm0_g)=0
.ic v(xdut.n_xarray/xi6/xi5/net4_xarray/xi6/xi5/mm1_g)=0.8
.ic v(xdut.n_xarray/xi6/xi9/net2_xarray/xi6/xi9/mm0_g)=0
.ic v(xdut.n_xarray/xi6/xi9/net4_xarray/xi6/xi9/mm1_g)=0.8
.ic v(xdut.n_xarray/xi6/xi13/net2_xarray/xi6/xi13/mm0_g)=0
.ic v(xdut.n_xarray/xi6/xi13/net4_xarray/xi6/xi13/mm1_g)=0.8
.ic v(xdut.n_xarray/xi6/xi17/net2_xarray/xi6/xi17/mm0_g)=0
.ic v(xdut.n_xarray/xi6/xi17/net4_xarray/xi6/xi17/mm1_g)=0.8
.ic v(xdut.n_xarray/xi6/xi21/net2_xarray/xi6/xi21/mm0_g)=0
.ic v(xdut.n_xarray/xi6/xi21/net4_xarray/xi6/xi21/mm1_g)=0.8
.ic v(xdut.n_xarray/xi6/xi25/net2_xarray/xi6/xi25/mm0_g)=0
.ic v(xdut.n_xarray/xi6/xi25/net4_xarray/xi6/xi25/mm1_g)=0.8
.ic v(xdut.n_xarray/xi6/xi29/net2_xarray/xi6/xi29/mm0_g)=0
.ic v(xdut.n_xarray/xi6/xi29/net4_xarray/xi6/xi29/mm1_g)=0.8
.ic v(xdut.n_xarray/xi6/xi33/net2_xarray/xi6/xi33/mm0_g)=0
.ic v(xdut.n_xarray/xi6/xi33/net4_xarray/xi6/xi33/mm1_g)=0.8
.ic v(xdut.n_xarray/xi6/xi6/net2_xarray/xi6/xi6/mm0_g)=0
.ic v(xdut.n_xarray/xi6/xi6/net4_xarray/xi6/xi6/mm1_g)=0.8
.ic v(xdut.n_xarray/xi6/xi10/net2_xarray/xi6/xi10/mm0_g)=0
.ic v(xdut.n_xarray/xi6/xi10/net4_xarray/xi6/xi10/mm1_g)=0.8
.ic v(xdut.n_xarray/xi6/xi14/net2_xarray/xi6/xi14/mm0_g)=0
.ic v(xdut.n_xarray/xi6/xi14/net4_xarray/xi6/xi14/mm1_g)=0.8
.ic v(xdut.n_xarray/xi6/xi18/net2_xarray/xi6/xi18/mm0_g)=0
.ic v(xdut.n_xarray/xi6/xi18/net4_xarray/xi6/xi18/mm1_g)=0.8
.ic v(xdut.n_xarray/xi6/xi22/net2_xarray/xi6/xi22/mm0_g)=0
.ic v(xdut.n_xarray/xi6/xi22/net4_xarray/xi6/xi22/mm1_g)=0.8
.ic v(xdut.n_xarray/xi6/xi26/net2_xarray/xi6/xi26/mm0_g)=0
.ic v(xdut.n_xarray/xi6/xi26/net4_xarray/xi6/xi26/mm1_g)=0.8
.ic v(xdut.n_xarray/xi6/xi30/net2_xarray/xi6/xi30/mm0_g)=0
.ic v(xdut.n_xarray/xi6/xi30/net4_xarray/xi6/xi30/mm1_g)=0.8
.ic v(xdut.n_xarray/xi6/xi34/net2_xarray/xi6/xi34/mm0_g)=0
.ic v(xdut.n_xarray/xi6/xi34/net4_xarray/xi6/xi34/mm1_g)=0.8
.ic v(xdut.n_xarray/xi6/xi7/net2_xarray/xi6/xi7/mm0_g)=0
.ic v(xdut.n_xarray/xi6/xi7/net4_xarray/xi6/xi7/mm1_g)=0.8
.ic v(xdut.n_xarray/xi6/xi11/net2_xarray/xi6/xi11/mm0_g)=0
.ic v(xdut.n_xarray/xi6/xi11/net4_xarray/xi6/xi11/mm1_g)=0.8
.ic v(xdut.n_xarray/xi6/xi15/net2_xarray/xi6/xi15/mm0_g)=0
.ic v(xdut.n_xarray/xi6/xi15/net4_xarray/xi6/xi15/mm1_g)=0.8
.ic v(xdut.n_xarray/xi6/xi19/net2_xarray/xi6/xi19/mm0_g)=0
.ic v(xdut.n_xarray/xi6/xi19/net4_xarray/xi6/xi19/mm1_g)=0.8
.ic v(xdut.n_xarray/xi6/xi23/net2_xarray/xi6/xi23/mm0_g)=0
.ic v(xdut.n_xarray/xi6/xi23/net4_xarray/xi6/xi23/mm1_g)=0.8
.ic v(xdut.n_xarray/xi6/xi27/net2_xarray/xi6/xi27/mm0_g)=0
.ic v(xdut.n_xarray/xi6/xi27/net4_xarray/xi6/xi27/mm1_g)=0.8
.ic v(xdut.n_xarray/xi6/xi31/net2_xarray/xi6/xi31/mm0_g)=0
.ic v(xdut.n_xarray/xi6/xi31/net4_xarray/xi6/xi31/mm1_g)=0.8
.ic v(xdut.n_xarray/xi6/xi35/net2_xarray/xi6/xi35/mm0_g)=0
.ic v(xdut.n_xarray/xi6/xi35/net4_xarray/xi6/xi35/mm1_g)=0.8
.ic v(xdut.n_xarray/xi6/xi8/net2_xarray/xi6/xi8/mm0_g)=0
.ic v(xdut.n_xarray/xi6/xi8/net4_xarray/xi6/xi8/mm1_g)=0.8
.ic v(xdut.n_xarray/xi6/xi12/net2_xarray/xi6/xi12/mm0_g)=0
.ic v(xdut.n_xarray/xi6/xi12/net4_xarray/xi6/xi12/mm1_g)=0.8
.ic v(xdut.n_xarray/xi6/xi16/net2_xarray/xi6/xi16/mm0_g)=0
.ic v(xdut.n_xarray/xi6/xi16/net4_xarray/xi6/xi16/mm1_g)=0.8
.ic v(xdut.n_xarray/xi6/xi20/net2_xarray/xi6/xi20/mm0_g)=0
.ic v(xdut.n_xarray/xi6/xi20/net4_xarray/xi6/xi20/mm1_g)=0.8
.ic v(xdut.n_xarray/xi6/xi24/net2_xarray/xi6/xi24/mm0_g)=0
.ic v(xdut.n_xarray/xi6/xi24/net4_xarray/xi6/xi24/mm1_g)=0.8
.ic v(xdut.n_xarray/xi6/xi28/net2_xarray/xi6/xi28/mm0_g)=0
.ic v(xdut.n_xarray/xi6/xi28/net4_xarray/xi6/xi28/mm1_g)=0.8
.ic v(xdut.n_xarray/xi6/xi32/net2_xarray/xi6/xi32/mm0_g)=0
.ic v(xdut.n_xarray/xi6/xi32/net4_xarray/xi6/xi32/mm1_g)=0.8
.ic v(xdut.n_xarray/xi6/xi36/net2_xarray/xi6/xi36/mm0_g)=0
.ic v(xdut.n_xarray/xi6/xi36/net4_xarray/xi6/xi36/mm1_g)=0.8
.ic v(xdut.n_xarray/xi5/xi5/net2_xarray/xi5/xi5/mm0_g)=0
.ic v(xdut.n_xarray/xi5/xi5/net4_xarray/xi5/xi5/mm1_g)=0.8
.ic v(xdut.n_xarray/xi5/xi9/net2_xarray/xi5/xi9/mm0_g)=0
.ic v(xdut.n_xarray/xi5/xi9/net4_xarray/xi5/xi9/mm1_g)=0.8
.ic v(xdut.n_xarray/xi5/xi13/net2_xarray/xi5/xi13/mm0_g)=0
.ic v(xdut.n_xarray/xi5/xi13/net4_xarray/xi5/xi13/mm1_g)=0.8
.ic v(xdut.n_xarray/xi5/xi17/net2_xarray/xi5/xi17/mm0_g)=0
.ic v(xdut.n_xarray/xi5/xi17/net4_xarray/xi5/xi17/mm1_g)=0.8
.ic v(xdut.n_xarray/xi5/xi21/net2_xarray/xi5/xi21/mm0_g)=0
.ic v(xdut.n_xarray/xi5/xi21/net4_xarray/xi5/xi21/mm1_g)=0.8
.ic v(xdut.n_xarray/xi5/xi25/net2_xarray/xi5/xi25/mm0_g)=0
.ic v(xdut.n_xarray/xi5/xi25/net4_xarray/xi5/xi25/mm1_g)=0.8
.ic v(xdut.n_xarray/xi5/xi29/net2_xarray/xi5/xi29/mm0_g)=0
.ic v(xdut.n_xarray/xi5/xi29/net4_xarray/xi5/xi29/mm1_g)=0.8
.ic v(xdut.n_xarray/xi5/xi33/net2_xarray/xi5/xi33/mm0_g)=0
.ic v(xdut.n_xarray/xi5/xi33/net4_xarray/xi5/xi33/mm1_g)=0.8
.ic v(xdut.n_xarray/xi5/xi6/net2_xarray/xi5/xi6/mm0_g)=0
.ic v(xdut.n_xarray/xi5/xi6/net4_xarray/xi5/xi6/mm1_g)=0.8
.ic v(xdut.n_xarray/xi5/xi10/net2_xarray/xi5/xi10/mm0_g)=0
.ic v(xdut.n_xarray/xi5/xi10/net4_xarray/xi5/xi10/mm1_g)=0.8
.ic v(xdut.n_xarray/xi5/xi14/net2_xarray/xi5/xi14/mm0_g)=0
.ic v(xdut.n_xarray/xi5/xi14/net4_xarray/xi5/xi14/mm1_g)=0.8
.ic v(xdut.n_xarray/xi5/xi18/net2_xarray/xi5/xi18/mm0_g)=0
.ic v(xdut.n_xarray/xi5/xi18/net4_xarray/xi5/xi18/mm1_g)=0.8
.ic v(xdut.n_xarray/xi5/xi22/net2_xarray/xi5/xi22/mm0_g)=0
.ic v(xdut.n_xarray/xi5/xi22/net4_xarray/xi5/xi22/mm1_g)=0.8
.ic v(xdut.n_xarray/xi5/xi26/net2_xarray/xi5/xi26/mm0_g)=0
.ic v(xdut.n_xarray/xi5/xi26/net4_xarray/xi5/xi26/mm1_g)=0.8
.ic v(xdut.n_xarray/xi5/xi30/net2_xarray/xi5/xi30/mm0_g)=0
.ic v(xdut.n_xarray/xi5/xi30/net4_xarray/xi5/xi30/mm1_g)=0.8
.ic v(xdut.n_xarray/xi5/xi34/net2_xarray/xi5/xi34/mm0_g)=0
.ic v(xdut.n_xarray/xi5/xi34/net4_xarray/xi5/xi34/mm1_g)=0.8
.ic v(xdut.n_xarray/xi5/xi7/net2_xarray/xi5/xi7/mm0_g)=0
.ic v(xdut.n_xarray/xi5/xi7/net4_xarray/xi5/xi7/mm1_g)=0.8
.ic v(xdut.n_xarray/xi5/xi11/net2_xarray/xi5/xi11/mm0_g)=0
.ic v(xdut.n_xarray/xi5/xi11/net4_xarray/xi5/xi11/mm1_g)=0.8
.ic v(xdut.n_xarray/xi5/xi15/net2_xarray/xi5/xi15/mm0_g)=0
.ic v(xdut.n_xarray/xi5/xi15/net4_xarray/xi5/xi15/mm1_g)=0.8
.ic v(xdut.n_xarray/xi5/xi19/net2_xarray/xi5/xi19/mm0_g)=0
.ic v(xdut.n_xarray/xi5/xi19/net4_xarray/xi5/xi19/mm1_g)=0.8
.ic v(xdut.n_xarray/xi5/xi23/net2_xarray/xi5/xi23/mm0_g)=0
.ic v(xdut.n_xarray/xi5/xi23/net4_xarray/xi5/xi23/mm1_g)=0.8
.ic v(xdut.n_xarray/xi5/xi27/net2_xarray/xi5/xi27/mm0_g)=0
.ic v(xdut.n_xarray/xi5/xi27/net4_xarray/xi5/xi27/mm1_g)=0.8
.ic v(xdut.n_xarray/xi5/xi31/net2_xarray/xi5/xi31/mm0_g)=0
.ic v(xdut.n_xarray/xi5/xi31/net4_xarray/xi5/xi31/mm1_g)=0.8
.ic v(xdut.n_xarray/xi5/xi35/net2_xarray/xi5/xi35/mm0_g)=0
.ic v(xdut.n_xarray/xi5/xi35/net4_xarray/xi5/xi35/mm1_g)=0.8
.ic v(xdut.n_xarray/xi5/xi8/net2_xarray/xi5/xi8/mm0_g)=0
.ic v(xdut.n_xarray/xi5/xi8/net4_xarray/xi5/xi8/mm1_g)=0.8
.ic v(xdut.n_xarray/xi5/xi12/net2_xarray/xi5/xi12/mm0_g)=0
.ic v(xdut.n_xarray/xi5/xi12/net4_xarray/xi5/xi12/mm1_g)=0.8
.ic v(xdut.n_xarray/xi5/xi16/net2_xarray/xi5/xi16/mm0_g)=0
.ic v(xdut.n_xarray/xi5/xi16/net4_xarray/xi5/xi16/mm1_g)=0.8
.ic v(xdut.n_xarray/xi5/xi20/net2_xarray/xi5/xi20/mm0_g)=0
.ic v(xdut.n_xarray/xi5/xi20/net4_xarray/xi5/xi20/mm1_g)=0.8
.ic v(xdut.n_xarray/xi5/xi24/net2_xarray/xi5/xi24/mm0_g)=0
.ic v(xdut.n_xarray/xi5/xi24/net4_xarray/xi5/xi24/mm1_g)=0.8
.ic v(xdut.n_xarray/xi5/xi28/net2_xarray/xi5/xi28/mm0_g)=0
.ic v(xdut.n_xarray/xi5/xi28/net4_xarray/xi5/xi28/mm1_g)=0.8
.ic v(xdut.n_xarray/xi5/xi32/net2_xarray/xi5/xi32/mm0_g)=0
.ic v(xdut.n_xarray/xi5/xi32/net4_xarray/xi5/xi32/mm1_g)=0.8
.ic v(xdut.n_xarray/xi5/xi36/net2_xarray/xi5/xi36/mm0_g)=0
.ic v(xdut.n_xarray/xi5/xi36/net4_xarray/xi5/xi36/mm1_g)=0.8
.ic v(xdut.n_xarray/xi4/xi5/net2_xarray/xi4/xi5/mm0_g)=0
.ic v(xdut.n_xarray/xi4/xi5/net4_xarray/xi4/xi5/mm1_g)=0.8
.ic v(xdut.n_xarray/xi4/xi9/net2_xarray/xi4/xi9/mm0_g)=0
.ic v(xdut.n_xarray/xi4/xi9/net4_xarray/xi4/xi9/mm1_g)=0.8
.ic v(xdut.n_xarray/xi4/xi13/net2_xarray/xi4/xi13/mm0_g)=0
.ic v(xdut.n_xarray/xi4/xi13/net4_xarray/xi4/xi13/mm1_g)=0.8
.ic v(xdut.n_xarray/xi4/xi17/net2_xarray/xi4/xi17/mm0_g)=0
.ic v(xdut.n_xarray/xi4/xi17/net4_xarray/xi4/xi17/mm1_g)=0.8
.ic v(xdut.n_xarray/xi4/xi21/net2_xarray/xi4/xi21/mm0_g)=0
.ic v(xdut.n_xarray/xi4/xi21/net4_xarray/xi4/xi21/mm1_g)=0.8
.ic v(xdut.n_xarray/xi4/xi25/net2_xarray/xi4/xi25/mm0_g)=0
.ic v(xdut.n_xarray/xi4/xi25/net4_xarray/xi4/xi25/mm1_g)=0.8
.ic v(xdut.n_xarray/xi4/xi29/net2_xarray/xi4/xi29/mm0_g)=0
.ic v(xdut.n_xarray/xi4/xi29/net4_xarray/xi4/xi29/mm1_g)=0.8
.ic v(xdut.n_xarray/xi4/xi33/net2_xarray/xi4/xi33/mm0_g)=0
.ic v(xdut.n_xarray/xi4/xi33/net4_xarray/xi4/xi33/mm1_g)=0.8
.ic v(xdut.n_xarray/xi4/xi6/net2_xarray/xi4/xi6/mm0_g)=0
.ic v(xdut.n_xarray/xi4/xi6/net4_xarray/xi4/xi6/mm1_g)=0.8
.ic v(xdut.n_xarray/xi4/xi10/net2_xarray/xi4/xi10/mm0_g)=0
.ic v(xdut.n_xarray/xi4/xi10/net4_xarray/xi4/xi10/mm1_g)=0.8
.ic v(xdut.n_xarray/xi4/xi14/net2_xarray/xi4/xi14/mm0_g)=0
.ic v(xdut.n_xarray/xi4/xi14/net4_xarray/xi4/xi14/mm1_g)=0.8
.ic v(xdut.n_xarray/xi4/xi18/net2_xarray/xi4/xi18/mm0_g)=0
.ic v(xdut.n_xarray/xi4/xi18/net4_xarray/xi4/xi18/mm1_g)=0.8
.ic v(xdut.n_xarray/xi4/xi22/net2_xarray/xi4/xi22/mm0_g)=0
.ic v(xdut.n_xarray/xi4/xi22/net4_xarray/xi4/xi22/mm1_g)=0.8
.ic v(xdut.n_xarray/xi4/xi26/net2_xarray/xi4/xi26/mm0_g)=0
.ic v(xdut.n_xarray/xi4/xi26/net4_xarray/xi4/xi26/mm1_g)=0.8
.ic v(xdut.n_xarray/xi4/xi30/net2_xarray/xi4/xi30/mm0_g)=0
.ic v(xdut.n_xarray/xi4/xi30/net4_xarray/xi4/xi30/mm1_g)=0.8
.ic v(xdut.n_xarray/xi4/xi34/net2_xarray/xi4/xi34/mm0_g)=0
.ic v(xdut.n_xarray/xi4/xi34/net4_xarray/xi4/xi34/mm1_g)=0.8
.ic v(xdut.n_xarray/xi4/xi7/net2_xarray/xi4/xi7/mm0_g)=0
.ic v(xdut.n_xarray/xi4/xi7/net4_xarray/xi4/xi7/mm1_g)=0.8
.ic v(xdut.n_xarray/xi4/xi11/net2_xarray/xi4/xi11/mm0_g)=0
.ic v(xdut.n_xarray/xi4/xi11/net4_xarray/xi4/xi11/mm1_g)=0.8
.ic v(xdut.n_xarray/xi4/xi15/net2_xarray/xi4/xi15/mm0_g)=0
.ic v(xdut.n_xarray/xi4/xi15/net4_xarray/xi4/xi15/mm1_g)=0.8
.ic v(xdut.n_xarray/xi4/xi19/net2_xarray/xi4/xi19/mm0_g)=0
.ic v(xdut.n_xarray/xi4/xi19/net4_xarray/xi4/xi19/mm1_g)=0.8
.ic v(xdut.n_xarray/xi4/xi23/net2_xarray/xi4/xi23/mm0_g)=0
.ic v(xdut.n_xarray/xi4/xi23/net4_xarray/xi4/xi23/mm1_g)=0.8
.ic v(xdut.n_xarray/xi4/xi27/net2_xarray/xi4/xi27/mm0_g)=0
.ic v(xdut.n_xarray/xi4/xi27/net4_xarray/xi4/xi27/mm1_g)=0.8
.ic v(xdut.n_xarray/xi4/xi31/net2_xarray/xi4/xi31/mm0_g)=0
.ic v(xdut.n_xarray/xi4/xi31/net4_xarray/xi4/xi31/mm1_g)=0.8
.ic v(xdut.n_xarray/xi4/xi35/net2_xarray/xi4/xi35/mm0_g)=0
.ic v(xdut.n_xarray/xi4/xi35/net4_xarray/xi4/xi35/mm1_g)=0.8
.ic v(xdut.n_xarray/xi4/xi8/net2_xarray/xi4/xi8/mm0_g)=0
.ic v(xdut.n_xarray/xi4/xi8/net4_xarray/xi4/xi8/mm1_g)=0.8
.ic v(xdut.n_xarray/xi4/xi12/net2_xarray/xi4/xi12/mm0_g)=0
.ic v(xdut.n_xarray/xi4/xi12/net4_xarray/xi4/xi12/mm1_g)=0.8
.ic v(xdut.n_xarray/xi4/xi16/net2_xarray/xi4/xi16/mm0_g)=0
.ic v(xdut.n_xarray/xi4/xi16/net4_xarray/xi4/xi16/mm1_g)=0.8
.ic v(xdut.n_xarray/xi4/xi20/net2_xarray/xi4/xi20/mm0_g)=0
.ic v(xdut.n_xarray/xi4/xi20/net4_xarray/xi4/xi20/mm1_g)=0.8
.ic v(xdut.n_xarray/xi4/xi24/net2_xarray/xi4/xi24/mm0_g)=0
.ic v(xdut.n_xarray/xi4/xi24/net4_xarray/xi4/xi24/mm1_g)=0.8
.ic v(xdut.n_xarray/xi4/xi28/net2_xarray/xi4/xi28/mm0_g)=0
.ic v(xdut.n_xarray/xi4/xi28/net4_xarray/xi4/xi28/mm1_g)=0.8
.ic v(xdut.n_xarray/xi4/xi32/net2_xarray/xi4/xi32/mm0_g)=0
.ic v(xdut.n_xarray/xi4/xi32/net4_xarray/xi4/xi32/mm1_g)=0.8
.ic v(xdut.n_xarray/xi4/xi36/net2_xarray/xi4/xi36/mm0_g)=0
.ic v(xdut.n_xarray/xi4/xi36/net4_xarray/xi4/xi36/mm1_g)=0.8
.ic v(xdut.n_xarray/xi3/xi5/net2_xarray/xi3/xi5/mm0_g)=0
.ic v(xdut.n_xarray/xi3/xi5/net4_xarray/xi3/xi5/mm1_g)=0.8
.ic v(xdut.n_xarray/xi3/xi9/net2_xarray/xi3/xi9/mm0_g)=0
.ic v(xdut.n_xarray/xi3/xi9/net4_xarray/xi3/xi9/mm1_g)=0.8
.ic v(xdut.n_xarray/xi3/xi13/net2_xarray/xi3/xi13/mm0_g)=0
.ic v(xdut.n_xarray/xi3/xi13/net4_xarray/xi3/xi13/mm1_g)=0.8
.ic v(xdut.n_xarray/xi3/xi17/net2_xarray/xi3/xi17/mm0_g)=0
.ic v(xdut.n_xarray/xi3/xi17/net4_xarray/xi3/xi17/mm1_g)=0.8
.ic v(xdut.n_xarray/xi3/xi21/net2_xarray/xi3/xi21/mm0_g)=0
.ic v(xdut.n_xarray/xi3/xi21/net4_xarray/xi3/xi21/mm1_g)=0.8
.ic v(xdut.n_xarray/xi3/xi25/net2_xarray/xi3/xi25/mm0_g)=0
.ic v(xdut.n_xarray/xi3/xi25/net4_xarray/xi3/xi25/mm1_g)=0.8
.ic v(xdut.n_xarray/xi3/xi29/net2_xarray/xi3/xi29/mm0_g)=0
.ic v(xdut.n_xarray/xi3/xi29/net4_xarray/xi3/xi29/mm1_g)=0.8
.ic v(xdut.n_xarray/xi3/xi33/net2_xarray/xi3/xi33/mm0_g)=0
.ic v(xdut.n_xarray/xi3/xi33/net4_xarray/xi3/xi33/mm1_g)=0.8
.ic v(xdut.n_xarray/xi3/xi6/net2_xarray/xi3/xi6/mm0_g)=0
.ic v(xdut.n_xarray/xi3/xi6/net4_xarray/xi3/xi6/mm1_g)=0.8
.ic v(xdut.n_xarray/xi3/xi10/net2_xarray/xi3/xi10/mm0_g)=0
.ic v(xdut.n_xarray/xi3/xi10/net4_xarray/xi3/xi10/mm1_g)=0.8
.ic v(xdut.n_xarray/xi3/xi14/net2_xarray/xi3/xi14/mm0_g)=0
.ic v(xdut.n_xarray/xi3/xi14/net4_xarray/xi3/xi14/mm1_g)=0.8
.ic v(xdut.n_xarray/xi3/xi18/net2_xarray/xi3/xi18/mm0_g)=0
.ic v(xdut.n_xarray/xi3/xi18/net4_xarray/xi3/xi18/mm1_g)=0.8
.ic v(xdut.n_xarray/xi3/xi22/net2_xarray/xi3/xi22/mm0_g)=0
.ic v(xdut.n_xarray/xi3/xi22/net4_xarray/xi3/xi22/mm1_g)=0.8
.ic v(xdut.n_xarray/xi3/xi26/net2_xarray/xi3/xi26/mm0_g)=0
.ic v(xdut.n_xarray/xi3/xi26/net4_xarray/xi3/xi26/mm1_g)=0.8
.ic v(xdut.n_xarray/xi3/xi30/net2_xarray/xi3/xi30/mm0_g)=0
.ic v(xdut.n_xarray/xi3/xi30/net4_xarray/xi3/xi30/mm1_g)=0.8
.ic v(xdut.n_xarray/xi3/xi34/net2_xarray/xi3/xi34/mm0_g)=0
.ic v(xdut.n_xarray/xi3/xi34/net4_xarray/xi3/xi34/mm1_g)=0.8
.ic v(xdut.n_xarray/xi3/xi7/net2_xarray/xi3/xi7/mm0_g)=0
.ic v(xdut.n_xarray/xi3/xi7/net4_xarray/xi3/xi7/mm1_g)=0.8
.ic v(xdut.n_xarray/xi3/xi11/net2_xarray/xi3/xi11/mm0_g)=0
.ic v(xdut.n_xarray/xi3/xi11/net4_xarray/xi3/xi11/mm1_g)=0.8
.ic v(xdut.n_xarray/xi3/xi15/net2_xarray/xi3/xi15/mm0_g)=0
.ic v(xdut.n_xarray/xi3/xi15/net4_xarray/xi3/xi15/mm1_g)=0.8
.ic v(xdut.n_xarray/xi3/xi19/net2_xarray/xi3/xi19/mm0_g)=0
.ic v(xdut.n_xarray/xi3/xi19/net4_xarray/xi3/xi19/mm1_g)=0.8
.ic v(xdut.n_xarray/xi3/xi23/net2_xarray/xi3/xi23/mm0_g)=0
.ic v(xdut.n_xarray/xi3/xi23/net4_xarray/xi3/xi23/mm1_g)=0.8
.ic v(xdut.n_xarray/xi3/xi27/net2_xarray/xi3/xi27/mm0_g)=0
.ic v(xdut.n_xarray/xi3/xi27/net4_xarray/xi3/xi27/mm1_g)=0.8
.ic v(xdut.n_xarray/xi3/xi31/net2_xarray/xi3/xi31/mm0_g)=0
.ic v(xdut.n_xarray/xi3/xi31/net4_xarray/xi3/xi31/mm1_g)=0.8
.ic v(xdut.n_xarray/xi3/xi35/net2_xarray/xi3/xi35/mm0_g)=0
.ic v(xdut.n_xarray/xi3/xi35/net4_xarray/xi3/xi35/mm1_g)=0.8
.ic v(xdut.n_xarray/xi3/xi8/net2_xarray/xi3/xi8/mm0_g)=0
.ic v(xdut.n_xarray/xi3/xi8/net4_xarray/xi3/xi8/mm1_g)=0.8
.ic v(xdut.n_xarray/xi3/xi12/net2_xarray/xi3/xi12/mm0_g)=0
.ic v(xdut.n_xarray/xi3/xi12/net4_xarray/xi3/xi12/mm1_g)=0.8
.ic v(xdut.n_xarray/xi3/xi16/net2_xarray/xi3/xi16/mm0_g)=0
.ic v(xdut.n_xarray/xi3/xi16/net4_xarray/xi3/xi16/mm1_g)=0.8
.ic v(xdut.n_xarray/xi3/xi20/net2_xarray/xi3/xi20/mm0_g)=0
.ic v(xdut.n_xarray/xi3/xi20/net4_xarray/xi3/xi20/mm1_g)=0.8
.ic v(xdut.n_xarray/xi3/xi24/net2_xarray/xi3/xi24/mm0_g)=0
.ic v(xdut.n_xarray/xi3/xi24/net4_xarray/xi3/xi24/mm1_g)=0.8
.ic v(xdut.n_xarray/xi3/xi28/net2_xarray/xi3/xi28/mm0_g)=0
.ic v(xdut.n_xarray/xi3/xi28/net4_xarray/xi3/xi28/mm1_g)=0.8
.ic v(xdut.n_xarray/xi3/xi32/net2_xarray/xi3/xi32/mm0_g)=0
.ic v(xdut.n_xarray/xi3/xi32/net4_xarray/xi3/xi32/mm1_g)=0.8
.ic v(xdut.n_xarray/xi3/xi36/net2_xarray/xi3/xi36/mm0_g)=0
.ic v(xdut.n_xarray/xi3/xi36/net4_xarray/xi3/xi36/mm1_g)=0.8
.ic v(xdut.n_xarray/xi2/xi5/net2_xarray/xi2/xi5/mm0_g)=0
.ic v(xdut.n_xarray/xi2/xi5/net4_xarray/xi2/xi5/mm1_g)=0.8
.ic v(xdut.n_xarray/xi2/xi9/net2_xarray/xi2/xi9/mm0_g)=0
.ic v(xdut.n_xarray/xi2/xi9/net4_xarray/xi2/xi9/mm1_g)=0.8
.ic v(xdut.n_xarray/xi2/xi13/net2_xarray/xi2/xi13/mm0_g)=0
.ic v(xdut.n_xarray/xi2/xi13/net4_xarray/xi2/xi13/mm1_g)=0.8
.ic v(xdut.n_xarray/xi2/xi17/net2_xarray/xi2/xi17/mm0_g)=0
.ic v(xdut.n_xarray/xi2/xi17/net4_xarray/xi2/xi17/mm1_g)=0.8
.ic v(xdut.n_xarray/xi2/xi21/net2_xarray/xi2/xi21/mm0_g)=0
.ic v(xdut.n_xarray/xi2/xi21/net4_xarray/xi2/xi21/mm1_g)=0.8
.ic v(xdut.n_xarray/xi2/xi25/net2_xarray/xi2/xi25/mm0_g)=0
.ic v(xdut.n_xarray/xi2/xi25/net4_xarray/xi2/xi25/mm1_g)=0.8
.ic v(xdut.n_xarray/xi2/xi29/net2_xarray/xi2/xi29/mm0_g)=0
.ic v(xdut.n_xarray/xi2/xi29/net4_xarray/xi2/xi29/mm1_g)=0.8
.ic v(xdut.n_xarray/xi2/xi33/net2_xarray/xi2/xi33/mm0_g)=0
.ic v(xdut.n_xarray/xi2/xi33/net4_xarray/xi2/xi33/mm1_g)=0.8
.ic v(xdut.n_xarray/xi2/xi6/net2_xarray/xi2/xi6/mm0_g)=0
.ic v(xdut.n_xarray/xi2/xi6/net4_xarray/xi2/xi6/mm1_g)=0.8
.ic v(xdut.n_xarray/xi2/xi10/net2_xarray/xi2/xi10/mm0_g)=0
.ic v(xdut.n_xarray/xi2/xi10/net4_xarray/xi2/xi10/mm1_g)=0.8
.ic v(xdut.n_xarray/xi2/xi14/net2_xarray/xi2/xi14/mm0_g)=0
.ic v(xdut.n_xarray/xi2/xi14/net4_xarray/xi2/xi14/mm1_g)=0.8
.ic v(xdut.n_xarray/xi2/xi18/net2_xarray/xi2/xi18/mm0_g)=0
.ic v(xdut.n_xarray/xi2/xi18/net4_xarray/xi2/xi18/mm1_g)=0.8
.ic v(xdut.n_xarray/xi2/xi22/net2_xarray/xi2/xi22/mm0_g)=0
.ic v(xdut.n_xarray/xi2/xi22/net4_xarray/xi2/xi22/mm1_g)=0.8
.ic v(xdut.n_xarray/xi2/xi26/net2_xarray/xi2/xi26/mm0_g)=0
.ic v(xdut.n_xarray/xi2/xi26/net4_xarray/xi2/xi26/mm1_g)=0.8
.ic v(xdut.n_xarray/xi2/xi30/net2_xarray/xi2/xi30/mm0_g)=0
.ic v(xdut.n_xarray/xi2/xi30/net4_xarray/xi2/xi30/mm1_g)=0.8
.ic v(xdut.n_xarray/xi2/xi34/net2_xarray/xi2/xi34/mm0_g)=0
.ic v(xdut.n_xarray/xi2/xi34/net4_xarray/xi2/xi34/mm1_g)=0.8
.ic v(xdut.n_xarray/xi2/xi7/net2_xarray/xi2/xi7/mm0_g)=0
.ic v(xdut.n_xarray/xi2/xi7/net4_xarray/xi2/xi7/mm1_g)=0.8
.ic v(xdut.n_xarray/xi2/xi11/net2_xarray/xi2/xi11/mm0_g)=0
.ic v(xdut.n_xarray/xi2/xi11/net4_xarray/xi2/xi11/mm1_g)=0.8
.ic v(xdut.n_xarray/xi2/xi15/net2_xarray/xi2/xi15/mm0_g)=0
.ic v(xdut.n_xarray/xi2/xi15/net4_xarray/xi2/xi15/mm1_g)=0.8
.ic v(xdut.n_xarray/xi2/xi19/net2_xarray/xi2/xi19/mm0_g)=0
.ic v(xdut.n_xarray/xi2/xi19/net4_xarray/xi2/xi19/mm1_g)=0.8
.ic v(xdut.n_xarray/xi2/xi23/net2_xarray/xi2/xi23/mm0_g)=0
.ic v(xdut.n_xarray/xi2/xi23/net4_xarray/xi2/xi23/mm1_g)=0.8
.ic v(xdut.n_xarray/xi2/xi27/net2_xarray/xi2/xi27/mm0_g)=0
.ic v(xdut.n_xarray/xi2/xi27/net4_xarray/xi2/xi27/mm1_g)=0.8
.ic v(xdut.n_xarray/xi2/xi31/net2_xarray/xi2/xi31/mm0_g)=0
.ic v(xdut.n_xarray/xi2/xi31/net4_xarray/xi2/xi31/mm1_g)=0.8
.ic v(xdut.n_xarray/xi2/xi35/net2_xarray/xi2/xi35/mm0_g)=0
.ic v(xdut.n_xarray/xi2/xi35/net4_xarray/xi2/xi35/mm1_g)=0.8
.ic v(xdut.n_xarray/xi2/xi8/net2_xarray/xi2/xi8/mm0_g)=0
.ic v(xdut.n_xarray/xi2/xi8/net4_xarray/xi2/xi8/mm1_g)=0.8
.ic v(xdut.n_xarray/xi2/xi12/net2_xarray/xi2/xi12/mm0_g)=0
.ic v(xdut.n_xarray/xi2/xi12/net4_xarray/xi2/xi12/mm1_g)=0.8
.ic v(xdut.n_xarray/xi2/xi16/net2_xarray/xi2/xi16/mm0_g)=0
.ic v(xdut.n_xarray/xi2/xi16/net4_xarray/xi2/xi16/mm1_g)=0.8
.ic v(xdut.n_xarray/xi2/xi20/net2_xarray/xi2/xi20/mm0_g)=0
.ic v(xdut.n_xarray/xi2/xi20/net4_xarray/xi2/xi20/mm1_g)=0.8
.ic v(xdut.n_xarray/xi2/xi24/net2_xarray/xi2/xi24/mm0_g)=0
.ic v(xdut.n_xarray/xi2/xi24/net4_xarray/xi2/xi24/mm1_g)=0.8
.ic v(xdut.n_xarray/xi2/xi28/net2_xarray/xi2/xi28/mm0_g)=0
.ic v(xdut.n_xarray/xi2/xi28/net4_xarray/xi2/xi28/mm1_g)=0.8
.ic v(xdut.n_xarray/xi2/xi32/net2_xarray/xi2/xi32/mm0_g)=0
.ic v(xdut.n_xarray/xi2/xi32/net4_xarray/xi2/xi32/mm1_g)=0.8
.ic v(xdut.n_xarray/xi2/xi36/net2_xarray/xi2/xi36/mm0_g)=0
.ic v(xdut.n_xarray/xi2/xi36/net4_xarray/xi2/xi36/mm1_g)=0.8
.ic v(xdut.n_xarray/xi1/xi5/net2_xarray/xi1/xi5/mm0_g)=0
.ic v(xdut.n_xarray/xi1/xi5/net4_xarray/xi1/xi5/mm1_g)=0.8
.ic v(xdut.n_xarray/xi1/xi9/net2_xarray/xi1/xi9/mm0_g)=0
.ic v(xdut.n_xarray/xi1/xi9/net4_xarray/xi1/xi9/mm1_g)=0.8
.ic v(xdut.n_xarray/xi1/xi13/net2_xarray/xi1/xi13/mm0_g)=0
.ic v(xdut.n_xarray/xi1/xi13/net4_xarray/xi1/xi13/mm1_g)=0.8
.ic v(xdut.n_xarray/xi1/xi17/net2_xarray/xi1/xi17/mm0_g)=0
.ic v(xdut.n_xarray/xi1/xi17/net4_xarray/xi1/xi17/mm1_g)=0.8
.ic v(xdut.n_xarray/xi1/xi21/net2_xarray/xi1/xi21/mm0_g)=0
.ic v(xdut.n_xarray/xi1/xi21/net4_xarray/xi1/xi21/mm1_g)=0.8
.ic v(xdut.n_xarray/xi1/xi25/net2_xarray/xi1/xi25/mm0_g)=0
.ic v(xdut.n_xarray/xi1/xi25/net4_xarray/xi1/xi25/mm1_g)=0.8
.ic v(xdut.n_xarray/xi1/xi29/net2_xarray/xi1/xi29/mm0_g)=0
.ic v(xdut.n_xarray/xi1/xi29/net4_xarray/xi1/xi29/mm1_g)=0.8
.ic v(xdut.n_xarray/xi1/xi33/net2_xarray/xi1/xi33/mm0_g)=0
.ic v(xdut.n_xarray/xi1/xi33/net4_xarray/xi1/xi33/mm1_g)=0.8
.ic v(xdut.n_xarray/xi1/xi6/net2_xarray/xi1/xi6/mm0_g)=0
.ic v(xdut.n_xarray/xi1/xi6/net4_xarray/xi1/xi6/mm1_g)=0.8
.ic v(xdut.n_xarray/xi1/xi10/net2_xarray/xi1/xi10/mm0_g)=0
.ic v(xdut.n_xarray/xi1/xi10/net4_xarray/xi1/xi10/mm1_g)=0.8
.ic v(xdut.n_xarray/xi1/xi14/net2_xarray/xi1/xi14/mm0_g)=0
.ic v(xdut.n_xarray/xi1/xi14/net4_xarray/xi1/xi14/mm1_g)=0.8
.ic v(xdut.n_xarray/xi1/xi18/net2_xarray/xi1/xi18/mm0_g)=0
.ic v(xdut.n_xarray/xi1/xi18/net4_xarray/xi1/xi18/mm1_g)=0.8
.ic v(xdut.n_xarray/xi1/xi22/net2_xarray/xi1/xi22/mm0_g)=0
.ic v(xdut.n_xarray/xi1/xi22/net4_xarray/xi1/xi22/mm1_g)=0.8
.ic v(xdut.n_xarray/xi1/xi26/net2_xarray/xi1/xi26/mm0_g)=0
.ic v(xdut.n_xarray/xi1/xi26/net4_xarray/xi1/xi26/mm1_g)=0.8
.ic v(xdut.n_xarray/xi1/xi30/net2_xarray/xi1/xi30/mm0_g)=0
.ic v(xdut.n_xarray/xi1/xi30/net4_xarray/xi1/xi30/mm1_g)=0.8
.ic v(xdut.n_xarray/xi1/xi34/net2_xarray/xi1/xi34/mm0_g)=0
.ic v(xdut.n_xarray/xi1/xi34/net4_xarray/xi1/xi34/mm1_g)=0.8
.ic v(xdut.n_xarray/xi1/xi7/net2_xarray/xi1/xi7/mm0_g)=0
.ic v(xdut.n_xarray/xi1/xi7/net4_xarray/xi1/xi7/mm1_g)=0.8
.ic v(xdut.n_xarray/xi1/xi11/net2_xarray/xi1/xi11/mm0_g)=0
.ic v(xdut.n_xarray/xi1/xi11/net4_xarray/xi1/xi11/mm1_g)=0.8
.ic v(xdut.n_xarray/xi1/xi15/net2_xarray/xi1/xi15/mm0_g)=0
.ic v(xdut.n_xarray/xi1/xi15/net4_xarray/xi1/xi15/mm1_g)=0.8
.ic v(xdut.n_xarray/xi1/xi19/net2_xarray/xi1/xi19/mm0_g)=0
.ic v(xdut.n_xarray/xi1/xi19/net4_xarray/xi1/xi19/mm1_g)=0.8
.ic v(xdut.n_xarray/xi1/xi23/net2_xarray/xi1/xi23/mm0_g)=0
.ic v(xdut.n_xarray/xi1/xi23/net4_xarray/xi1/xi23/mm1_g)=0.8
.ic v(xdut.n_xarray/xi1/xi27/net2_xarray/xi1/xi27/mm0_g)=0
.ic v(xdut.n_xarray/xi1/xi27/net4_xarray/xi1/xi27/mm1_g)=0.8
.ic v(xdut.n_xarray/xi1/xi31/net2_xarray/xi1/xi31/mm0_g)=0
.ic v(xdut.n_xarray/xi1/xi31/net4_xarray/xi1/xi31/mm1_g)=0.8
.ic v(xdut.n_xarray/xi1/xi35/net2_xarray/xi1/xi35/mm0_g)=0
.ic v(xdut.n_xarray/xi1/xi35/net4_xarray/xi1/xi35/mm1_g)=0.8
.ic v(xdut.n_xarray/xi1/xi8/net2_xarray/xi1/xi8/mm0_g)=0
.ic v(xdut.n_xarray/xi1/xi8/net4_xarray/xi1/xi8/mm1_g)=0.8
.ic v(xdut.n_xarray/xi1/xi12/net2_xarray/xi1/xi12/mm0_g)=0
.ic v(xdut.n_xarray/xi1/xi12/net4_xarray/xi1/xi12/mm1_g)=0.8
.ic v(xdut.n_xarray/xi1/xi16/net2_xarray/xi1/xi16/mm0_g)=0
.ic v(xdut.n_xarray/xi1/xi16/net4_xarray/xi1/xi16/mm1_g)=0.8
.ic v(xdut.n_xarray/xi1/xi20/net2_xarray/xi1/xi20/mm0_g)=0
.ic v(xdut.n_xarray/xi1/xi20/net4_xarray/xi1/xi20/mm1_g)=0.8
.ic v(xdut.n_xarray/xi1/xi24/net2_xarray/xi1/xi24/mm0_g)=0
.ic v(xdut.n_xarray/xi1/xi24/net4_xarray/xi1/xi24/mm1_g)=0.8
.ic v(xdut.n_xarray/xi1/xi28/net2_xarray/xi1/xi28/mm0_g)=0
.ic v(xdut.n_xarray/xi1/xi28/net4_xarray/xi1/xi28/mm1_g)=0.8
.ic v(xdut.n_xarray/xi1/xi32/net2_xarray/xi1/xi32/mm0_g)=0
.ic v(xdut.n_xarray/xi1/xi32/net4_xarray/xi1/xi32/mm1_g)=0.8
.ic v(xdut.n_xarray/xi1/xi36/net2_xarray/xi1/xi36/mm0_g)=0
.ic v(xdut.n_xarray/xi1/xi36/net4_xarray/xi1/xi36/mm1_g)=0.8
.ic v(xdut.n_xarray/xi0/xi5/net2_xarray/xi0/xi5/mm0_g)=0
.ic v(xdut.n_xarray/xi0/xi5/net4_xarray/xi0/xi5/mm1_g)=0.8
.ic v(xdut.n_xarray/xi0/xi9/net2_xarray/xi0/xi9/mm0_g)=0
.ic v(xdut.n_xarray/xi0/xi9/net4_xarray/xi0/xi9/mm1_g)=0.8
.ic v(xdut.n_xarray/xi0/xi13/net2_xarray/xi0/xi13/mm0_g)=0
.ic v(xdut.n_xarray/xi0/xi13/net4_xarray/xi0/xi13/mm1_g)=0.8
.ic v(xdut.n_xarray/xi0/xi17/net2_xarray/xi0/xi17/mm0_g)=0
.ic v(xdut.n_xarray/xi0/xi17/net4_xarray/xi0/xi17/mm1_g)=0.8
.ic v(xdut.n_xarray/xi0/xi21/net2_xarray/xi0/xi21/mm0_g)=0
.ic v(xdut.n_xarray/xi0/xi21/net4_xarray/xi0/xi21/mm1_g)=0.8
.ic v(xdut.n_xarray/xi0/xi25/net2_xarray/xi0/xi25/mm0_g)=0
.ic v(xdut.n_xarray/xi0/xi25/net4_xarray/xi0/xi25/mm1_g)=0.8
.ic v(xdut.n_xarray/xi0/xi29/net2_xarray/xi0/xi29/mm0_g)=0
.ic v(xdut.n_xarray/xi0/xi29/net4_xarray/xi0/xi29/mm1_g)=0.8
.ic v(xdut.n_xarray/xi0/xi33/net2_xarray/xi0/xi33/mm0_g)=0
.ic v(xdut.n_xarray/xi0/xi33/net4_xarray/xi0/xi33/mm1_g)=0.8
.ic v(xdut.n_xarray/xi0/xi6/net2_xarray/xi0/xi6/mm0_g)=0
.ic v(xdut.n_xarray/xi0/xi6/net4_xarray/xi0/xi6/mm1_g)=0.8
.ic v(xdut.n_xarray/xi0/xi10/net2_xarray/xi0/xi10/mm0_g)=0
.ic v(xdut.n_xarray/xi0/xi10/net4_xarray/xi0/xi10/mm1_g)=0.8
.ic v(xdut.n_xarray/xi0/xi14/net2_xarray/xi0/xi14/mm0_g)=0
.ic v(xdut.n_xarray/xi0/xi14/net4_xarray/xi0/xi14/mm1_g)=0.8
.ic v(xdut.n_xarray/xi0/xi18/net2_xarray/xi0/xi18/mm0_g)=0
.ic v(xdut.n_xarray/xi0/xi18/net4_xarray/xi0/xi18/mm1_g)=0.8
.ic v(xdut.n_xarray/xi0/xi22/net2_xarray/xi0/xi22/mm0_g)=0
.ic v(xdut.n_xarray/xi0/xi22/net4_xarray/xi0/xi22/mm1_g)=0.8
.ic v(xdut.n_xarray/xi0/xi26/net2_xarray/xi0/xi26/mm0_g)=0
.ic v(xdut.n_xarray/xi0/xi26/net4_xarray/xi0/xi26/mm1_g)=0.8
.ic v(xdut.n_xarray/xi0/xi30/net2_xarray/xi0/xi30/mm0_g)=0
.ic v(xdut.n_xarray/xi0/xi30/net4_xarray/xi0/xi30/mm1_g)=0.8
.ic v(xdut.n_xarray/xi0/xi34/net2_xarray/xi0/xi34/mm0_g)=0
.ic v(xdut.n_xarray/xi0/xi34/net4_xarray/xi0/xi34/mm1_g)=0.8
.ic v(xdut.n_xarray/xi0/xi7/net2_xarray/xi0/xi7/mm0_g)=0
.ic v(xdut.n_xarray/xi0/xi7/net4_xarray/xi0/xi7/mm1_g)=0.8
.ic v(xdut.n_xarray/xi0/xi11/net2_xarray/xi0/xi11/mm0_g)=0
.ic v(xdut.n_xarray/xi0/xi11/net4_xarray/xi0/xi11/mm1_g)=0.8
.ic v(xdut.n_xarray/xi0/xi15/net2_xarray/xi0/xi15/mm0_g)=0
.ic v(xdut.n_xarray/xi0/xi15/net4_xarray/xi0/xi15/mm1_g)=0.8
.ic v(xdut.n_xarray/xi0/xi19/net2_xarray/xi0/xi19/mm0_g)=0
.ic v(xdut.n_xarray/xi0/xi19/net4_xarray/xi0/xi19/mm1_g)=0.8
.ic v(xdut.n_xarray/xi0/xi23/net2_xarray/xi0/xi23/mm0_g)=0
.ic v(xdut.n_xarray/xi0/xi23/net4_xarray/xi0/xi23/mm1_g)=0.8
.ic v(xdut.n_xarray/xi0/xi27/net2_xarray/xi0/xi27/mm0_g)=0
.ic v(xdut.n_xarray/xi0/xi27/net4_xarray/xi0/xi27/mm1_g)=0.8
.ic v(xdut.n_xarray/xi0/xi31/net2_xarray/xi0/xi31/mm0_g)=0
.ic v(xdut.n_xarray/xi0/xi31/net4_xarray/xi0/xi31/mm1_g)=0.8
.ic v(xdut.n_xarray/xi0/xi35/net2_xarray/xi0/xi35/mm0_g)=0
.ic v(xdut.n_xarray/xi0/xi35/net4_xarray/xi0/xi35/mm1_g)=0.8
.ic v(xdut.n_xarray/xi0/xi8/net2_xarray/xi0/xi8/mm0_g)=0
.ic v(xdut.n_xarray/xi0/xi8/net4_xarray/xi0/xi8/mm1_g)=0.8
.ic v(xdut.n_xarray/xi0/xi12/net2_xarray/xi0/xi12/mm0_g)=0
.ic v(xdut.n_xarray/xi0/xi12/net4_xarray/xi0/xi12/mm1_g)=0.8
.ic v(xdut.n_xarray/xi0/xi16/net2_xarray/xi0/xi16/mm0_g)=0
.ic v(xdut.n_xarray/xi0/xi16/net4_xarray/xi0/xi16/mm1_g)=0.8
.ic v(xdut.n_xarray/xi0/xi20/net2_xarray/xi0/xi20/mm0_g)=0
.ic v(xdut.n_xarray/xi0/xi20/net4_xarray/xi0/xi20/mm1_g)=0.8
.ic v(xdut.n_xarray/xi0/xi24/net2_xarray/xi0/xi24/mm0_g)=0
.ic v(xdut.n_xarray/xi0/xi24/net4_xarray/xi0/xi24/mm1_g)=0.8
.ic v(xdut.n_xarray/xi0/xi28/net2_xarray/xi0/xi28/mm0_g)=0
.ic v(xdut.n_xarray/xi0/xi28/net4_xarray/xi0/xi28/mm1_g)=0.8
.ic v(xdut.n_xarray/xi0/xi32/net2_xarray/xi0/xi32/mm0_g)=0
.ic v(xdut.n_xarray/xi0/xi32/net4_xarray/xi0/xi32/mm1_g)=0.8
.ic v(xdut.n_xarray/xi0/xi36/net2_xarray/xi0/xi36/mm0_g)=0
.ic v(xdut.n_xarray/xi0/xi36/net4_xarray/xi0/xi36/mm1_g)=0.8
.tran 5.0p 35.000000000n
V_SUP VDD 0 0.8
V_pre_b pre_b 0 PWL(0.000000000n 0 2.180000000n 0 2.230000000n 0.8 2.820000000n 0.8 2.870000000n 0 3.180000000n 0 3.230000000n 0.8 3.820000000n 0.8 3.870000000n 0 4.180000000n 0 4.230000000n 0.8 4.820000000n 0.8 4.870000000n 0 5.180000000n 0 5.230000000n 0.8 5.820000000n 0.8 5.870000000n 0 6.180000000n 0 6.230000000n 0.8 6.820000000n 0.8 6.870000000n 0 7.180000000n 0 7.230000000n 0.8 7.820000000n 0.8 7.870000000n 0 8.180000000n 0 8.230000000n 0.8 8.820000000n 0.8 8.870000000n 0 9.180000000n 0 9.230000000n 0.8 9.820000000n 0.8 9.870000000n 0 10.180000000n 0 10.230000000n 0.8 10.820000000n 0.8 10.870000000n 0 11.180000000n 0 11.230000000n 0.8 11.820000000n 0.8 11.870000000n 0 12.180000000n 0 12.230000000n 0.8 12.820000000n 0.8 12.870000000n 0 13.180000000n 0 13.230000000n 0.8 13.820000000n 0.8 13.870000000n 0 14.180000000n 0 14.230000000n 0.8 14.820000000n 0.8 14.870000000n 0 15.180000000n 0 15.230000000n 0.8 15.820000000n 0.8 15.870000000n 0 16.180000000n 0 16.230000000n 0.8 16.820000000n 0.8 16.870000000n 0 17.180000000n 0 17.230000000n 0.8 17.820000000n 0.8 17.870000000n 0 18.180000000n 0 18.230000000n 0.8 18.820000000n 0.8 18.870000000n 0 19.180000000n 0 19.230000000n 0.8 19.820000000n 0.8 19.870000000n 0 20.180000000n 0 20.230000000n 0.8 20.820000000n 0.8 20.870000000n 0 21.180000000n 0 21.230000000n 0.8 21.820000000n 0.8 21.870000000n 0 22.180000000n 0 22.230000000n 0.8 22.820000000n 0.8 22.870000000n 0 23.180000000n 0 23.230000000n 0.8 23.820000000n 0.8 23.870000000n 0 24.180000000n 0 24.230000000n 0.8 24.820000000n 0.8 24.870000000n 0 25.180000000n 0 25.230000000n 0.8 25.820000000n 0.8 25.870000000n 0 26.180000000n 0 26.230000000n 0.8 26.820000000n 0.8 26.870000000n 0 27.180000000n 0 27.230000000n 0.8 27.820000000n 0.8 27.870000000n 0 28.180000000n 0 28.230000000n 0.8 28.820000000n 0.8 28.870000000n 0 29.180000000n 0 29.230000000n 0.8 29.820000000n 0.8 29.870000000n 0 30.180000000n 0 30.230000000n 0.8 30.820000000n 0.8 30.870000000n 0 31.180000000n 0 31.230000000n 0.8 31.820000000n 0.8 31.870000000n 0 32.180000000n 0 32.230000000n 0.8 32.820000000n 0.8 32.870000000n 0 33.180000000n 0 33.230000000n 0.8 33.820000000n 0.8 33.870000000n 0)
V_we we 0 PWL(0.000000000n 0 2.250000000n 0 2.300000000n 0.8 2.580000000n 0.8 2.630000000n 0 4.250000000n 0 4.300000000n 0.8 4.580000000n 0.8 4.630000000n 0 6.250000000n 0 6.300000000n 0.8 6.580000000n 0.8 6.630000000n 0 8.250000000n 0 8.300000000n 0.8 8.580000000n 0.8 8.630000000n 0 10.250000000n 0 10.300000000n 0.8 10.580000000n 0.8 10.630000000n 0 12.250000000n 0 12.300000000n 0.8 12.580000000n 0.8 12.630000000n 0 14.250000000n 0 14.300000000n 0.8 14.580000000n 0.8 14.630000000n 0 16.250000000n 0 16.300000000n 0.8 16.580000000n 0.8 16.630000000n 0 18.250000000n 0 18.300000000n 0.8 18.580000000n 0.8 18.630000000n 0 20.250000000n 0 20.300000000n 0.8 20.580000000n 0.8 20.630000000n 0 22.250000000n 0 22.300000000n 0.8 22.580000000n 0.8 22.630000000n 0 24.250000000n 0 24.300000000n 0.8 24.580000000n 0.8 24.630000000n 0 26.250000000n 0 26.300000000n 0.8 26.580000000n 0.8 26.630000000n 0 28.250000000n 0 28.300000000n 0.8 28.580000000n 0.8 28.630000000n 0 30.250000000n 0 30.300000000n 0.8 30.580000000n 0.8 30.630000000n 0 32.250000000n 0 32.300000000n 0.8 32.580000000n 0.8 32.630000000n 0)
V_web web 0 PWL(0.000000000n 0.8 2.250000000n 0.8 2.300000000n 0 2.580000000n 0 2.630000000n 0.8 4.250000000n 0.8 4.300000000n 0 4.580000000n 0 4.630000000n 0.8 6.250000000n 0.8 6.300000000n 0 6.580000000n 0 6.630000000n 0.8 8.250000000n 0.8 8.300000000n 0 8.580000000n 0 8.630000000n 0.8 10.250000000n 0.8 10.300000000n 0 10.580000000n 0 10.630000000n 0.8 12.250000000n 0.8 12.300000000n 0 12.580000000n 0 12.630000000n 0.8 14.250000000n 0.8 14.300000000n 0 14.580000000n 0 14.630000000n 0.8 16.250000000n 0.8 16.300000000n 0 16.580000000n 0 16.630000000n 0.8 18.250000000n 0.8 18.300000000n 0 18.580000000n 0 18.630000000n 0.8 20.250000000n 0.8 20.300000000n 0 20.580000000n 0 20.630000000n 0.8 22.250000000n 0.8 22.300000000n 0 22.580000000n 0 22.630000000n 0.8 24.250000000n 0.8 24.300000000n 0 24.580000000n 0 24.630000000n 0.8 26.250000000n 0.8 26.300000000n 0 26.580000000n 0 26.630000000n 0.8 28.250000000n 0.8 28.300000000n 0 28.580000000n 0 28.630000000n 0.8 30.250000000n 0.8 30.300000000n 0 30.580000000n 0 30.630000000n 0.8 32.250000000n 0.8 32.300000000n 0 32.580000000n 0 32.630000000n 0.8)
V_sae sae 0 PWL(0.000000000n 0 3.460000000n 0 3.510000000n 0.8 3.800000000n 0.8 3.850000000n 0 5.460000000n 0 5.510000000n 0.8 5.800000000n 0.8 5.850000000n 0 7.460000000n 0 7.510000000n 0.8 7.800000000n 0.8 7.850000000n 0 9.460000000n 0 9.510000000n 0.8 9.800000000n 0.8 9.850000000n 0 11.460000000n 0 11.510000000n 0.8 11.800000000n 0.8 11.850000000n 0 13.460000000n 0 13.510000000n 0.8 13.800000000n 0.8 13.850000000n 0 15.460000000n 0 15.510000000n 0.8 15.800000000n 0.8 15.850000000n 0 17.460000000n 0 17.510000000n 0.8 17.800000000n 0.8 17.850000000n 0 19.460000000n 0 19.510000000n 0.8 19.800000000n 0.8 19.850000000n 0 21.460000000n 0 21.510000000n 0.8 21.800000000n 0.8 21.850000000n 0 23.460000000n 0 23.510000000n 0.8 23.800000000n 0.8 23.850000000n 0 25.460000000n 0 25.510000000n 0.8 25.800000000n 0.8 25.850000000n 0 27.460000000n 0 27.510000000n 0.8 27.800000000n 0.8 27.850000000n 0 29.460000000n 0 29.510000000n 0.8 29.800000000n 0.8 29.850000000n 0 31.460000000n 0 31.510000000n 0.8 31.800000000n 0.8 31.850000000n 0 33.460000000n 0 33.510000000n 0.8 33.800000000n 0.8 33.850000000n 0)

V_CLK clk 0 PULSE(0 0.8 1.975n 50p 50p 450p 1n)
.include "simulation/common/row_decoder_front.sp"

V_row_en row_en 0 PWL(0.000000000n 0 2.050000000n 0 2.100000000n 0.8 2.475000000n 0.8 2.525000000n 0 3.050000000n 0 3.100000000n 0.8 3.475000000n 0.8 3.525000000n 0 4.050000000n 0 4.100000000n 0.8 4.475000000n 0.8 4.525000000n 0 5.050000000n 0 5.100000000n 0.8 5.475000000n 0.8 5.525000000n 0 6.050000000n 0 6.100000000n 0.8 6.475000000n 0.8 6.525000000n 0 7.050000000n 0 7.100000000n 0.8 7.475000000n 0.8 7.525000000n 0 8.050000000n 0 8.100000000n 0.8 8.475000000n 0.8 8.525000000n 0 9.050000000n 0 9.100000000n 0.8 9.475000000n 0.8 9.525000000n 0 10.050000000n 0 10.100000000n 0.8 10.475000000n 0.8 10.525000000n 0 11.050000000n 0 11.100000000n 0.8 11.475000000n 0.8 11.525000000n 0 12.050000000n 0 12.100000000n 0.8 12.475000000n 0.8 12.525000000n 0 13.050000000n 0 13.100000000n 0.8 13.475000000n 0.8 13.525000000n 0 14.050000000n 0 14.100000000n 0.8 14.475000000n 0.8 14.525000000n 0 15.050000000n 0 15.100000000n 0.8 15.475000000n 0.8 15.525000000n 0 16.050000000n 0 16.100000000n 0.8 16.475000000n 0.8 16.525000000n 0 17.050000000n 0 17.100000000n 0.8 17.475000000n 0.8 17.525000000n 0 18.050000000n 0 18.100000000n 0.8 18.475000000n 0.8 18.525000000n 0 19.050000000n 0 19.100000000n 0.8 19.475000000n 0.8 19.525000000n 0 20.050000000n 0 20.100000000n 0.8 20.475000000n 0.8 20.525000000n 0 21.050000000n 0 21.100000000n 0.8 21.475000000n 0.8 21.525000000n 0 22.050000000n 0 22.100000000n 0.8 22.475000000n 0.8 22.525000000n 0 23.050000000n 0 23.100000000n 0.8 23.475000000n 0.8 23.525000000n 0 24.050000000n 0 24.100000000n 0.8 24.475000000n 0.8 24.525000000n 0 25.050000000n 0 25.100000000n 0.8 25.475000000n 0.8 25.525000000n 0 26.050000000n 0 26.100000000n 0.8 26.475000000n 0.8 26.525000000n 0 27.050000000n 0 27.100000000n 0.8 27.475000000n 0.8 27.525000000n 0 28.050000000n 0 28.100000000n 0.8 28.475000000n 0.8 28.525000000n 0 29.050000000n 0 29.100000000n 0.8 29.475000000n 0.8 29.525000000n 0 30.050000000n 0 30.100000000n 0.8 30.475000000n 0.8 30.525000000n 0 31.050000000n 0 31.100000000n 0.8 31.475000000n 0.8 31.525000000n 0 32.050000000n 0 32.100000000n 0.8 32.475000000n 0.8 32.525000000n 0 33.050000000n 0 33.100000000n 0.8 33.475000000n 0.8 33.525000000n 0)
XFRONT ra0 ra1 ra2 ra3 in<0> in<1> in<2> in<3> in<4> in<5> in<6> in<7> in<8> in<9> in<10> in<11> in<12> in<13> in<14> in<15> VDD 0 row_en ROW_DECODER_FRONT
.include "simulation/common/registers_decoder.sp"
.include "@MODELS@/NMOS_VTG.inc"
.include "@MODELS@/PMOS_VTG.inc"
V_CLKB clk_b 0 PULSE(0.8 0 1.975n 50p 50p 450p 1n)
V_aext0 aext0 0 PWL(0.000000000n 0 9.750000000n 0 9.800000000n 0.8 17.750000000n 0.8 17.800000000n 0.0 25.750000000n 0.0 25.800000000n 0.8)
XA0 clk clk_b aext0 ra0 ab0 vdd 0 dff
V_aext1 aext1 0 PWL(0.000000000n 0 9.750000000n 0 9.800000000n 0.8 17.750000000n 0.8 17.800000000n 0.0 25.750000000n 0.0 25.800000000n 0.8)
XA1 clk clk_b aext1 ra1 ab1 vdd 0 dff
V_aext2 aext2 0 PWL(0.000000000n 0 9.750000000n 0 9.800000000n 0.8 17.750000000n 0.8 17.800000000n 0.0 25.750000000n 0.0 25.800000000n 0.8)
XA2 clk clk_b aext2 ra2 ab2 vdd 0 dff
V_aext3 aext3 0 PWL(0.000000000n 0 9.750000000n 0 9.800000000n 0.8 17.750000000n 0.8 17.800000000n 0.0 25.750000000n 0.0 25.800000000n 0.8)
XA3 clk clk_b aext3 ra3 ab3 vdd 0 dff
V_aext4 aext4 0 PWL(0.000000000n 0 3.750000000n 0 3.800000000n 0.8 5.750000000n 0.8 5.800000000n 0.0 7.750000000n 0.0 7.800000000n 0.8 9.750000000n 0.8 9.800000000n 0.0 11.750000000n 0.0 11.800000000n 0.8 13.750000000n 0.8 13.800000000n 0.0 15.750000000n 0.0 15.800000000n 0.8 17.750000000n 0.8 17.800000000n 0.0 19.750000000n 0.0 19.800000000n 0.8 21.750000000n 0.8 21.800000000n 0.0 23.750000000n 0.0 23.800000000n 0.8 25.750000000n 0.8 25.800000000n 0.0 27.750000000n 0.0 27.800000000n 0.8 29.750000000n 0.8 29.800000000n 0.0 31.750000000n 0.0 31.800000000n 0.8)
XA4 clk clk_b aext4 ca0 ab4 vdd 0 dff
V_aext5 aext5 0 PWL(0.000000000n 0 5.750000000n 0 5.800000000n 0.8 9.750000000n 0.8 9.800000000n 0.0 13.750000000n 0.0 13.800000000n 0.8 17.750000000n 0.8 17.800000000n 0.0 21.750000000n 0.0 21.800000000n 0.8 25.750000000n 0.8 25.800000000n 0.0 29.750000000n 0.0 29.800000000n 0.8)
XA5 clk clk_b aext5 ca1 ab5 vdd 0 dff
V_dext0 dext0 0 PWL(0.000000000n 0 3.750000000n 0 3.800000000n 0.8 5.750000000n 0.8 5.800000000n 0.0 7.750000000n 0.0 7.800000000n 0.8 11.750000000n 0.8 11.800000000n 0.0 13.750000000n 0.0 13.800000000n 0.8 15.750000000n 0.8 15.800000000n 0.0 17.750000000n 0.0 17.800000000n 0.8 19.750000000n 0.8 19.800000000n 0.0 21.750000000n 0.0 21.800000000n 0.8 23.750000000n 0.8 23.800000000n 0.0 27.750000000n 0.0 27.800000000n 0.8 29.750000000n 0.8 29.800000000n 0.0 31.750000000n 0.0 31.800000000n 0.8)
XD0 clk clk_b dext0 din<0> db0 vdd 0 dff
XO0 clk clk_b dout<0> rout0 rb0 vdd 0 dff
CL0 rout0 0 10f
V_dext1 dext1 0 PWL(0.000000000n 0 1.750000000n 0 1.800000000n 0.8 3.750000000n 0.8 3.800000000n 0.0 5.750000000n 0.0 5.800000000n 0.8 7.750000000n 0.8 7.800000000n 0.0 11.750000000n 0.0 11.800000000n 0.8 13.750000000n 0.8 13.800000000n 0.0 15.750000000n 0.0 15.800000000n 0.8 17.750000000n 0.8 17.800000000n 0.0 19.750000000n 0.0 19.800000000n 0.8 21.750000000n 0.8 21.800000000n 0.0 23.750000000n 0.0 23.800000000n 0.8 27.750000000n 0.8 27.800000000n 0.0 29.750000000n 0.0 29.800000000n 0.8 31.750000000n 0.8 31.800000000n 0.0)
XD1 clk clk_b dext1 din<1> db1 vdd 0 dff
XO1 clk clk_b dout<1> rout1 rb1 vdd 0 dff
CL1 rout1 0 10f
V_dext2 dext2 0 PWL(0.000000000n 0 3.750000000n 0 3.800000000n 0.8 5.750000000n 0.8 5.800000000n 0.0 7.750000000n 0.0 7.800000000n 0.8 11.750000000n 0.8 11.800000000n 0.0 13.750000000n 0.0 13.800000000n 0.8 15.750000000n 0.8 15.800000000n 0.0 17.750000000n 0.0 17.800000000n 0.8 19.750000000n 0.8 19.800000000n 0.0 21.750000000n 0.0 21.800000000n 0.8 23.750000000n 0.8 23.800000000n 0.0 27.750000000n 0.0 27.800000000n 0.8 29.750000000n 0.8 29.800000000n 0.0 31.750000000n 0.0 31.800000000n 0.8)
XD2 clk clk_b dext2 din<2> db2 vdd 0 dff
XO2 clk clk_b dout<2> rout2 rb2 vdd 0 dff
CL2 rout2 0 10f
V_dext3 dext3 0 PWL(0.000000000n 0 1.750000000n 0 1.800000000n 0.8 3.750000000n 0.8 3.800000000n 0.0 5.750000000n 0.0 5.800000000n 0.8 7.750000000n 0.8 7.800000000n 0.0 11.750000000n 0.0 11.800000000n 0.8 13.750000000n 0.8 13.800000000n 0.0 15.750000000n 0.0 15.800000000n 0.8 17.750000000n 0.8 17.800000000n 0.0 19.750000000n 0.0 19.800000000n 0.8 21.750000000n 0.8 21.800000000n 0.0 23.750000000n 0.0 23.800000000n 0.8 27.750000000n 0.8 27.800000000n 0.0 29.750000000n 0.0 29.800000000n 0.8 31.750000000n 0.8 31.800000000n 0.0)
XD3 clk clk_b dext3 din<3> db3 vdd 0 dff
XO3 clk clk_b dout<3> rout3 rb3 vdd 0 dff
CL3 rout3 0 10f
V_dext4 dext4 0 PWL(0.000000000n 0 3.750000000n 0 3.800000000n 0.8 5.750000000n 0.8 5.800000000n 0.0 7.750000000n 0.0 7.800000000n 0.8 11.750000000n 0.8 11.800000000n 0.0 13.750000000n 0.0 13.800000000n 0.8 15.750000000n 0.8 15.800000000n 0.0 17.750000000n 0.0 17.800000000n 0.8 19.750000000n 0.8 19.800000000n 0.0 21.750000000n 0.0 21.800000000n 0.8 23.750000000n 0.8 23.800000000n 0.0 27.750000000n 0.0 27.800000000n 0.8 29.750000000n 0.8 29.800000000n 0.0 31.750000000n 0.0 31.800000000n 0.8)
XD4 clk clk_b dext4 din<4> db4 vdd 0 dff
XO4 clk clk_b dout<4> rout4 rb4 vdd 0 dff
CL4 rout4 0 10f
V_dext5 dext5 0 PWL(0.000000000n 0 1.750000000n 0 1.800000000n 0.8 3.750000000n 0.8 3.800000000n 0.0 5.750000000n 0.0 5.800000000n 0.8 7.750000000n 0.8 7.800000000n 0.0 11.750000000n 0.0 11.800000000n 0.8 13.750000000n 0.8 13.800000000n 0.0 15.750000000n 0.0 15.800000000n 0.8 17.750000000n 0.8 17.800000000n 0.0 19.750000000n 0.0 19.800000000n 0.8 21.750000000n 0.8 21.800000000n 0.0 23.750000000n 0.0 23.800000000n 0.8 27.750000000n 0.8 27.800000000n 0.0 29.750000000n 0.0 29.800000000n 0.8 31.750000000n 0.8 31.800000000n 0.0)
XD5 clk clk_b dext5 din<5> db5 vdd 0 dff
XO5 clk clk_b dout<5> rout5 rb5 vdd 0 dff
CL5 rout5 0 10f
V_dext6 dext6 0 PWL(0.000000000n 0 3.750000000n 0 3.800000000n 0.8 5.750000000n 0.8 5.800000000n 0.0 7.750000000n 0.0 7.800000000n 0.8 11.750000000n 0.8 11.800000000n 0.0 13.750000000n 0.0 13.800000000n 0.8 15.750000000n 0.8 15.800000000n 0.0 17.750000000n 0.0 17.800000000n 0.8 19.750000000n 0.8 19.800000000n 0.0 21.750000000n 0.0 21.800000000n 0.8 23.750000000n 0.8 23.800000000n 0.0 27.750000000n 0.0 27.800000000n 0.8 29.750000000n 0.8 29.800000000n 0.0 31.750000000n 0.0 31.800000000n 0.8)
XD6 clk clk_b dext6 din<6> db6 vdd 0 dff
XO6 clk clk_b dout<6> rout6 rb6 vdd 0 dff
CL6 rout6 0 10f
V_dext7 dext7 0 PWL(0.000000000n 0 1.750000000n 0 1.800000000n 0.8 3.750000000n 0.8 3.800000000n 0.0 5.750000000n 0.0 5.800000000n 0.8 7.750000000n 0.8 7.800000000n 0.0 11.750000000n 0.0 11.800000000n 0.8 13.750000000n 0.8 13.800000000n 0.0 15.750000000n 0.0 15.800000000n 0.8 17.750000000n 0.8 17.800000000n 0.0 19.750000000n 0.0 19.800000000n 0.8 21.750000000n 0.8 21.800000000n 0.0 23.750000000n 0.0 23.800000000n 0.8 27.750000000n 0.8 27.800000000n 0.0 29.750000000n 0.0 29.800000000n 0.8 31.750000000n 0.8 31.800000000n 0.0)
XD7 clk clk_b dext7 din<7> db7 vdd 0 dff
XO7 clk clk_b dout<7> rout7 rb7 vdd 0 dff
CL7 rout7 0 10f
XCOL vdd ca0 ca1 col_sel<0> col_sel<1> col_sel<2> col_sel<3> col_sel_b<0> col_sel_b<1> col_sel_b<2> col_sel_b<3> vdd 0 dec2x4
E_TRACE_pre pre 0 pre_b 0 1
E_TRACE_wl wl 0 xdut.n_wl<0>_xarray/xi0/xi36/mm5_g 0 1
E_TRACE_sel sel 0 col_sel<0> 0 1
E_TRACE_ra ra 0 ra0 0 1
E_TRACE_ca ca 0 ca0 0 1
E_TRACE_di di 0 din<0> 0 1
E_TRACE_out out 0 dout<0> 0 1
E_TRACE_reg reg 0 rout0 0 1
E_TRACE_dl dl 0 dl<0> 0 1
E_TRACE_dlb dlb 0 dlb<0> 0 1
E_TRACE_q q 0 xdut.n_xarray/xi0/xi5/net2_xarray/xi0/xi5/mm0_g 0 1
E_TRACE_qb qb 0 xdut.n_xarray/xi0/xi5/net4_xarray/xi0/xi5/mm1_g 0 1
E_out1 out1 0 dout<1> 0 1
E_reg1 reg1 0 rout1 0 1
E_dl1 dl1 0 dl<1> 0 1
E_dlb1 dlb1 0 dlb<1> 0 1
E_out2 out2 0 dout<2> 0 1
E_reg2 reg2 0 rout2 0 1
E_dl2 dl2 0 dl<2> 0 1
E_dlb2 dlb2 0 dlb<2> 0 1
E_out3 out3 0 dout<3> 0 1
E_reg3 reg3 0 rout3 0 1
E_dl3 dl3 0 dl<3> 0 1
E_dlb3 dlb3 0 dlb<3> 0 1
E_out4 out4 0 dout<4> 0 1
E_reg4 reg4 0 rout4 0 1
E_dl4 dl4 0 dl<4> 0 1
E_dlb4 dlb4 0 dlb<4> 0 1
E_out5 out5 0 dout<5> 0 1
E_reg5 reg5 0 rout5 0 1
E_dl5 dl5 0 dl<5> 0 1
E_dlb5 dlb5 0 dlb<5> 0 1
E_out6 out6 0 dout<6> 0 1
E_reg6 reg6 0 rout6 0 1
E_dl6 dl6 0 dl<6> 0 1
E_dlb6 dlb6 0 dlb<6> 0 1
E_out7 out7 0 dout<7> 0 1
E_reg7 reg7 0 rout7 0 1
E_dl7 dl7 0 dl<7> 0 1
E_dlb7 dlb7 0 dlb<7> 0 1
.print tran v(clk) v(pre) v(we) v(sae) v(wl) v(sel) v(ra) v(ca) v(di) v(out) v(reg) v(dl) v(dlb) v(q) v(qb) v(out1) v(reg1) v(dl1) v(dlb1) v(out2) v(reg2) v(dl2) v(dlb2) v(out3) v(reg3) v(dl3) v(dlb3) v(out4) v(reg4) v(dl4) v(dlb4) v(out5) v(reg5) v(dl5) v(dlb5) v(out6) v(reg6) v(dl6) v(dlb6) v(out7) v(reg7) v(dl7) v(dlb7)
.measure tran w000b0 FIND v(xdut.n_xarray/xi0/xi5/net2_xarray/xi0/xi5/mm0_g) AT=2.630000000n
.measure tran w000b1 FIND v(xdut.n_xarray/xi0/xi9/net2_xarray/xi0/xi9/mm0_g) AT=2.630000000n
.measure tran w000b2 FIND v(xdut.n_xarray/xi0/xi13/net2_xarray/xi0/xi13/mm0_g) AT=2.630000000n
.measure tran w000b3 FIND v(xdut.n_xarray/xi0/xi17/net2_xarray/xi0/xi17/mm0_g) AT=2.630000000n
.measure tran w000b4 FIND v(xdut.n_xarray/xi0/xi21/net2_xarray/xi0/xi21/mm0_g) AT=2.630000000n
.measure tran w000b5 FIND v(xdut.n_xarray/xi0/xi25/net2_xarray/xi0/xi25/mm0_g) AT=2.630000000n
.measure tran w000b6 FIND v(xdut.n_xarray/xi0/xi29/net2_xarray/xi0/xi29/mm0_g) AT=2.630000000n
.measure tran w000b7 FIND v(xdut.n_xarray/xi0/xi33/net2_xarray/xi0/xi33/mm0_g) AT=2.630000000n
.measure tran w001b0 FIND v(xdut.n_xarray/xi0/xi6/net2_xarray/xi0/xi6/mm0_g) AT=4.630000000n
.measure tran w001b1 FIND v(xdut.n_xarray/xi0/xi10/net2_xarray/xi0/xi10/mm0_g) AT=4.630000000n
.measure tran w001b2 FIND v(xdut.n_xarray/xi0/xi14/net2_xarray/xi0/xi14/mm0_g) AT=4.630000000n
.measure tran w001b3 FIND v(xdut.n_xarray/xi0/xi18/net2_xarray/xi0/xi18/mm0_g) AT=4.630000000n
.measure tran w001b4 FIND v(xdut.n_xarray/xi0/xi22/net2_xarray/xi0/xi22/mm0_g) AT=4.630000000n
.measure tran w001b5 FIND v(xdut.n_xarray/xi0/xi26/net2_xarray/xi0/xi26/mm0_g) AT=4.630000000n
.measure tran w001b6 FIND v(xdut.n_xarray/xi0/xi30/net2_xarray/xi0/xi30/mm0_g) AT=4.630000000n
.measure tran w001b7 FIND v(xdut.n_xarray/xi0/xi34/net2_xarray/xi0/xi34/mm0_g) AT=4.630000000n
.measure tran w002b0 FIND v(xdut.n_xarray/xi0/xi7/net2_xarray/xi0/xi7/mm0_g) AT=6.630000000n
.measure tran w002b1 FIND v(xdut.n_xarray/xi0/xi11/net2_xarray/xi0/xi11/mm0_g) AT=6.630000000n
.measure tran w002b2 FIND v(xdut.n_xarray/xi0/xi15/net2_xarray/xi0/xi15/mm0_g) AT=6.630000000n
.measure tran w002b3 FIND v(xdut.n_xarray/xi0/xi19/net2_xarray/xi0/xi19/mm0_g) AT=6.630000000n
.measure tran w002b4 FIND v(xdut.n_xarray/xi0/xi23/net2_xarray/xi0/xi23/mm0_g) AT=6.630000000n
.measure tran w002b5 FIND v(xdut.n_xarray/xi0/xi27/net2_xarray/xi0/xi27/mm0_g) AT=6.630000000n
.measure tran w002b6 FIND v(xdut.n_xarray/xi0/xi31/net2_xarray/xi0/xi31/mm0_g) AT=6.630000000n
.measure tran w002b7 FIND v(xdut.n_xarray/xi0/xi35/net2_xarray/xi0/xi35/mm0_g) AT=6.630000000n
.measure tran w003b0 FIND v(xdut.n_xarray/xi0/xi8/net2_xarray/xi0/xi8/mm0_g) AT=8.630000000n
.measure tran w003b1 FIND v(xdut.n_xarray/xi0/xi12/net2_xarray/xi0/xi12/mm0_g) AT=8.630000000n
.measure tran w003b2 FIND v(xdut.n_xarray/xi0/xi16/net2_xarray/xi0/xi16/mm0_g) AT=8.630000000n
.measure tran w003b3 FIND v(xdut.n_xarray/xi0/xi20/net2_xarray/xi0/xi20/mm0_g) AT=8.630000000n
.measure tran w003b4 FIND v(xdut.n_xarray/xi0/xi24/net2_xarray/xi0/xi24/mm0_g) AT=8.630000000n
.measure tran w003b5 FIND v(xdut.n_xarray/xi0/xi28/net2_xarray/xi0/xi28/mm0_g) AT=8.630000000n
.measure tran w003b6 FIND v(xdut.n_xarray/xi0/xi32/net2_xarray/xi0/xi32/mm0_g) AT=8.630000000n
.measure tran w003b7 FIND v(xdut.n_xarray/xi0/xi36/net2_xarray/xi0/xi36/mm0_g) AT=8.630000000n
.measure tran w004b0 FIND v(xdut.n_xarray/xi15/xi5/net2_xarray/xi15/xi5/mm0_g) AT=10.630000000n
.measure tran w004b1 FIND v(xdut.n_xarray/xi15/xi9/net2_xarray/xi15/xi9/mm0_g) AT=10.630000000n
.measure tran w004b2 FIND v(xdut.n_xarray/xi15/xi13/net2_xarray/xi15/xi13/mm0_g) AT=10.630000000n
.measure tran w004b3 FIND v(xdut.n_xarray/xi15/xi17/net2_xarray/xi15/xi17/mm0_g) AT=10.630000000n
.measure tran w004b4 FIND v(xdut.n_xarray/xi15/xi21/net2_xarray/xi15/xi21/mm0_g) AT=10.630000000n
.measure tran w004b5 FIND v(xdut.n_xarray/xi15/xi25/net2_xarray/xi15/xi25/mm0_g) AT=10.630000000n
.measure tran w004b6 FIND v(xdut.n_xarray/xi15/xi29/net2_xarray/xi15/xi29/mm0_g) AT=10.630000000n
.measure tran w004b7 FIND v(xdut.n_xarray/xi15/xi33/net2_xarray/xi15/xi33/mm0_g) AT=10.630000000n
.measure tran w005b0 FIND v(xdut.n_xarray/xi15/xi6/net2_xarray/xi15/xi6/mm0_g) AT=12.630000000n
.measure tran w005b1 FIND v(xdut.n_xarray/xi15/xi10/net2_xarray/xi15/xi10/mm0_g) AT=12.630000000n
.measure tran w005b2 FIND v(xdut.n_xarray/xi15/xi14/net2_xarray/xi15/xi14/mm0_g) AT=12.630000000n
.measure tran w005b3 FIND v(xdut.n_xarray/xi15/xi18/net2_xarray/xi15/xi18/mm0_g) AT=12.630000000n
.measure tran w005b4 FIND v(xdut.n_xarray/xi15/xi22/net2_xarray/xi15/xi22/mm0_g) AT=12.630000000n
.measure tran w005b5 FIND v(xdut.n_xarray/xi15/xi26/net2_xarray/xi15/xi26/mm0_g) AT=12.630000000n
.measure tran w005b6 FIND v(xdut.n_xarray/xi15/xi30/net2_xarray/xi15/xi30/mm0_g) AT=12.630000000n
.measure tran w005b7 FIND v(xdut.n_xarray/xi15/xi34/net2_xarray/xi15/xi34/mm0_g) AT=12.630000000n
.measure tran w006b0 FIND v(xdut.n_xarray/xi15/xi7/net2_xarray/xi15/xi7/mm0_g) AT=14.630000000n
.measure tran w006b1 FIND v(xdut.n_xarray/xi15/xi11/net2_xarray/xi15/xi11/mm0_g) AT=14.630000000n
.measure tran w006b2 FIND v(xdut.n_xarray/xi15/xi15/net2_xarray/xi15/xi15/mm0_g) AT=14.630000000n
.measure tran w006b3 FIND v(xdut.n_xarray/xi15/xi19/net2_xarray/xi15/xi19/mm0_g) AT=14.630000000n
.measure tran w006b4 FIND v(xdut.n_xarray/xi15/xi23/net2_xarray/xi15/xi23/mm0_g) AT=14.630000000n
.measure tran w006b5 FIND v(xdut.n_xarray/xi15/xi27/net2_xarray/xi15/xi27/mm0_g) AT=14.630000000n
.measure tran w006b6 FIND v(xdut.n_xarray/xi15/xi31/net2_xarray/xi15/xi31/mm0_g) AT=14.630000000n
.measure tran w006b7 FIND v(xdut.n_xarray/xi15/xi35/net2_xarray/xi15/xi35/mm0_g) AT=14.630000000n
.measure tran w007b0 FIND v(xdut.n_xarray/xi15/xi8/net2_xarray/xi15/xi8/mm0_g) AT=16.630000000n
.measure tran w007b1 FIND v(xdut.n_xarray/xi15/xi12/net2_xarray/xi15/xi12/mm0_g) AT=16.630000000n
.measure tran w007b2 FIND v(xdut.n_xarray/xi15/xi16/net2_xarray/xi15/xi16/mm0_g) AT=16.630000000n
.measure tran w007b3 FIND v(xdut.n_xarray/xi15/xi20/net2_xarray/xi15/xi20/mm0_g) AT=16.630000000n
.measure tran w007b4 FIND v(xdut.n_xarray/xi15/xi24/net2_xarray/xi15/xi24/mm0_g) AT=16.630000000n
.measure tran w007b5 FIND v(xdut.n_xarray/xi15/xi28/net2_xarray/xi15/xi28/mm0_g) AT=16.630000000n
.measure tran w007b6 FIND v(xdut.n_xarray/xi15/xi32/net2_xarray/xi15/xi32/mm0_g) AT=16.630000000n
.measure tran w007b7 FIND v(xdut.n_xarray/xi15/xi36/net2_xarray/xi15/xi36/mm0_g) AT=16.630000000n
.measure tran r008b0 FIND v(dout<0>) AT=3.940000000n
.measure tran s008b0 MAX v(dout<0>) FROM=3.940000000n TO=3.990000000n
.measure tran d008b0 FIND par('v(dl<0>)-v(dlb<0>)') AT=3.580000000n
.measure tran r008b1 FIND v(dout<1>) AT=3.940000000n
.measure tran s008b1 MIN v(dout<1>) FROM=3.940000000n TO=3.990000000n
.measure tran d008b1 FIND par('v(dl<1>)-v(dlb<1>)') AT=3.580000000n
.measure tran r008b2 FIND v(dout<2>) AT=3.940000000n
.measure tran s008b2 MAX v(dout<2>) FROM=3.940000000n TO=3.990000000n
.measure tran d008b2 FIND par('v(dl<2>)-v(dlb<2>)') AT=3.580000000n
.measure tran r008b3 FIND v(dout<3>) AT=3.940000000n
.measure tran s008b3 MIN v(dout<3>) FROM=3.940000000n TO=3.990000000n
.measure tran d008b3 FIND par('v(dl<3>)-v(dlb<3>)') AT=3.580000000n
.measure tran r008b4 FIND v(dout<4>) AT=3.940000000n
.measure tran s008b4 MAX v(dout<4>) FROM=3.940000000n TO=3.990000000n
.measure tran d008b4 FIND par('v(dl<4>)-v(dlb<4>)') AT=3.580000000n
.measure tran r008b5 FIND v(dout<5>) AT=3.940000000n
.measure tran s008b5 MIN v(dout<5>) FROM=3.940000000n TO=3.990000000n
.measure tran d008b5 FIND par('v(dl<5>)-v(dlb<5>)') AT=3.580000000n
.measure tran r008b6 FIND v(dout<6>) AT=3.940000000n
.measure tran s008b6 MAX v(dout<6>) FROM=3.940000000n TO=3.990000000n
.measure tran d008b6 FIND par('v(dl<6>)-v(dlb<6>)') AT=3.580000000n
.measure tran r008b7 FIND v(dout<7>) AT=3.940000000n
.measure tran s008b7 MIN v(dout<7>) FROM=3.940000000n TO=3.990000000n
.measure tran d008b7 FIND par('v(dl<7>)-v(dlb<7>)') AT=3.580000000n
.measure tran r009b0 FIND v(dout<0>) AT=5.940000000n
.measure tran s009b0 MIN v(dout<0>) FROM=5.940000000n TO=5.990000000n
.measure tran d009b0 FIND par('v(dl<0>)-v(dlb<0>)') AT=5.580000000n
.measure tran r009b1 FIND v(dout<1>) AT=5.940000000n
.measure tran s009b1 MAX v(dout<1>) FROM=5.940000000n TO=5.990000000n
.measure tran d009b1 FIND par('v(dl<1>)-v(dlb<1>)') AT=5.580000000n
.measure tran r009b2 FIND v(dout<2>) AT=5.940000000n
.measure tran s009b2 MIN v(dout<2>) FROM=5.940000000n TO=5.990000000n
.measure tran d009b2 FIND par('v(dl<2>)-v(dlb<2>)') AT=5.580000000n
.measure tran r009b3 FIND v(dout<3>) AT=5.940000000n
.measure tran s009b3 MAX v(dout<3>) FROM=5.940000000n TO=5.990000000n
.measure tran d009b3 FIND par('v(dl<3>)-v(dlb<3>)') AT=5.580000000n
.measure tran r009b4 FIND v(dout<4>) AT=5.940000000n
.measure tran s009b4 MIN v(dout<4>) FROM=5.940000000n TO=5.990000000n
.measure tran d009b4 FIND par('v(dl<4>)-v(dlb<4>)') AT=5.580000000n
.measure tran r009b5 FIND v(dout<5>) AT=5.940000000n
.measure tran s009b5 MAX v(dout<5>) FROM=5.940000000n TO=5.990000000n
.measure tran d009b5 FIND par('v(dl<5>)-v(dlb<5>)') AT=5.580000000n
.measure tran r009b6 FIND v(dout<6>) AT=5.940000000n
.measure tran s009b6 MIN v(dout<6>) FROM=5.940000000n TO=5.990000000n
.measure tran d009b6 FIND par('v(dl<6>)-v(dlb<6>)') AT=5.580000000n
.measure tran r009b7 FIND v(dout<7>) AT=5.940000000n
.measure tran s009b7 MAX v(dout<7>) FROM=5.940000000n TO=5.990000000n
.measure tran d009b7 FIND par('v(dl<7>)-v(dlb<7>)') AT=5.580000000n
.measure tran r010b0 FIND v(dout<0>) AT=7.940000000n
.measure tran s010b0 MAX v(dout<0>) FROM=7.940000000n TO=7.990000000n
.measure tran d010b0 FIND par('v(dl<0>)-v(dlb<0>)') AT=7.580000000n
.measure tran r010b1 FIND v(dout<1>) AT=7.940000000n
.measure tran s010b1 MIN v(dout<1>) FROM=7.940000000n TO=7.990000000n
.measure tran d010b1 FIND par('v(dl<1>)-v(dlb<1>)') AT=7.580000000n
.measure tran r010b2 FIND v(dout<2>) AT=7.940000000n
.measure tran s010b2 MAX v(dout<2>) FROM=7.940000000n TO=7.990000000n
.measure tran d010b2 FIND par('v(dl<2>)-v(dlb<2>)') AT=7.580000000n
.measure tran r010b3 FIND v(dout<3>) AT=7.940000000n
.measure tran s010b3 MIN v(dout<3>) FROM=7.940000000n TO=7.990000000n
.measure tran d010b3 FIND par('v(dl<3>)-v(dlb<3>)') AT=7.580000000n
.measure tran r010b4 FIND v(dout<4>) AT=7.940000000n
.measure tran s010b4 MAX v(dout<4>) FROM=7.940000000n TO=7.990000000n
.measure tran d010b4 FIND par('v(dl<4>)-v(dlb<4>)') AT=7.580000000n
.measure tran r010b5 FIND v(dout<5>) AT=7.940000000n
.measure tran s010b5 MIN v(dout<5>) FROM=7.940000000n TO=7.990000000n
.measure tran d010b5 FIND par('v(dl<5>)-v(dlb<5>)') AT=7.580000000n
.measure tran r010b6 FIND v(dout<6>) AT=7.940000000n
.measure tran s010b6 MAX v(dout<6>) FROM=7.940000000n TO=7.990000000n
.measure tran d010b6 FIND par('v(dl<6>)-v(dlb<6>)') AT=7.580000000n
.measure tran r010b7 FIND v(dout<7>) AT=7.940000000n
.measure tran s010b7 MIN v(dout<7>) FROM=7.940000000n TO=7.990000000n
.measure tran d010b7 FIND par('v(dl<7>)-v(dlb<7>)') AT=7.580000000n
.measure tran r011b0 FIND v(dout<0>) AT=9.940000000n
.measure tran s011b0 MIN v(dout<0>) FROM=9.940000000n TO=9.990000000n
.measure tran d011b0 FIND par('v(dl<0>)-v(dlb<0>)') AT=9.580000000n
.measure tran r011b1 FIND v(dout<1>) AT=9.940000000n
.measure tran s011b1 MAX v(dout<1>) FROM=9.940000000n TO=9.990000000n
.measure tran d011b1 FIND par('v(dl<1>)-v(dlb<1>)') AT=9.580000000n
.measure tran r011b2 FIND v(dout<2>) AT=9.940000000n
.measure tran s011b2 MIN v(dout<2>) FROM=9.940000000n TO=9.990000000n
.measure tran d011b2 FIND par('v(dl<2>)-v(dlb<2>)') AT=9.580000000n
.measure tran r011b3 FIND v(dout<3>) AT=9.940000000n
.measure tran s011b3 MAX v(dout<3>) FROM=9.940000000n TO=9.990000000n
.measure tran d011b3 FIND par('v(dl<3>)-v(dlb<3>)') AT=9.580000000n
.measure tran r011b4 FIND v(dout<4>) AT=9.940000000n
.measure tran s011b4 MIN v(dout<4>) FROM=9.940000000n TO=9.990000000n
.measure tran d011b4 FIND par('v(dl<4>)-v(dlb<4>)') AT=9.580000000n
.measure tran r011b5 FIND v(dout<5>) AT=9.940000000n
.measure tran s011b5 MAX v(dout<5>) FROM=9.940000000n TO=9.990000000n
.measure tran d011b5 FIND par('v(dl<5>)-v(dlb<5>)') AT=9.580000000n
.measure tran r011b6 FIND v(dout<6>) AT=9.940000000n
.measure tran s011b6 MIN v(dout<6>) FROM=9.940000000n TO=9.990000000n
.measure tran d011b6 FIND par('v(dl<6>)-v(dlb<6>)') AT=9.580000000n
.measure tran r011b7 FIND v(dout<7>) AT=9.940000000n
.measure tran s011b7 MAX v(dout<7>) FROM=9.940000000n TO=9.990000000n
.measure tran d011b7 FIND par('v(dl<7>)-v(dlb<7>)') AT=9.580000000n
.measure tran r012b0 FIND v(dout<0>) AT=11.940000000n
.measure tran s012b0 MIN v(dout<0>) FROM=11.940000000n TO=11.990000000n
.measure tran d012b0 FIND par('v(dl<0>)-v(dlb<0>)') AT=11.580000000n
.measure tran r012b1 FIND v(dout<1>) AT=11.940000000n
.measure tran s012b1 MAX v(dout<1>) FROM=11.940000000n TO=11.990000000n
.measure tran d012b1 FIND par('v(dl<1>)-v(dlb<1>)') AT=11.580000000n
.measure tran r012b2 FIND v(dout<2>) AT=11.940000000n
.measure tran s012b2 MIN v(dout<2>) FROM=11.940000000n TO=11.990000000n
.measure tran d012b2 FIND par('v(dl<2>)-v(dlb<2>)') AT=11.580000000n
.measure tran r012b3 FIND v(dout<3>) AT=11.940000000n
.measure tran s012b3 MAX v(dout<3>) FROM=11.940000000n TO=11.990000000n
.measure tran d012b3 FIND par('v(dl<3>)-v(dlb<3>)') AT=11.580000000n
.measure tran r012b4 FIND v(dout<4>) AT=11.940000000n
.measure tran s012b4 MIN v(dout<4>) FROM=11.940000000n TO=11.990000000n
.measure tran d012b4 FIND par('v(dl<4>)-v(dlb<4>)') AT=11.580000000n
.measure tran r012b5 FIND v(dout<5>) AT=11.940000000n
.measure tran s012b5 MAX v(dout<5>) FROM=11.940000000n TO=11.990000000n
.measure tran d012b5 FIND par('v(dl<5>)-v(dlb<5>)') AT=11.580000000n
.measure tran r012b6 FIND v(dout<6>) AT=11.940000000n
.measure tran s012b6 MIN v(dout<6>) FROM=11.940000000n TO=11.990000000n
.measure tran d012b6 FIND par('v(dl<6>)-v(dlb<6>)') AT=11.580000000n
.measure tran r012b7 FIND v(dout<7>) AT=11.940000000n
.measure tran s012b7 MAX v(dout<7>) FROM=11.940000000n TO=11.990000000n
.measure tran d012b7 FIND par('v(dl<7>)-v(dlb<7>)') AT=11.580000000n
.measure tran r013b0 FIND v(dout<0>) AT=13.940000000n
.measure tran s013b0 MAX v(dout<0>) FROM=13.940000000n TO=13.990000000n
.measure tran d013b0 FIND par('v(dl<0>)-v(dlb<0>)') AT=13.580000000n
.measure tran r013b1 FIND v(dout<1>) AT=13.940000000n
.measure tran s013b1 MIN v(dout<1>) FROM=13.940000000n TO=13.990000000n
.measure tran d013b1 FIND par('v(dl<1>)-v(dlb<1>)') AT=13.580000000n
.measure tran r013b2 FIND v(dout<2>) AT=13.940000000n
.measure tran s013b2 MAX v(dout<2>) FROM=13.940000000n TO=13.990000000n
.measure tran d013b2 FIND par('v(dl<2>)-v(dlb<2>)') AT=13.580000000n
.measure tran r013b3 FIND v(dout<3>) AT=13.940000000n
.measure tran s013b3 MIN v(dout<3>) FROM=13.940000000n TO=13.990000000n
.measure tran d013b3 FIND par('v(dl<3>)-v(dlb<3>)') AT=13.580000000n
.measure tran r013b4 FIND v(dout<4>) AT=13.940000000n
.measure tran s013b4 MAX v(dout<4>) FROM=13.940000000n TO=13.990000000n
.measure tran d013b4 FIND par('v(dl<4>)-v(dlb<4>)') AT=13.580000000n
.measure tran r013b5 FIND v(dout<5>) AT=13.940000000n
.measure tran s013b5 MIN v(dout<5>) FROM=13.940000000n TO=13.990000000n
.measure tran d013b5 FIND par('v(dl<5>)-v(dlb<5>)') AT=13.580000000n
.measure tran r013b6 FIND v(dout<6>) AT=13.940000000n
.measure tran s013b6 MAX v(dout<6>) FROM=13.940000000n TO=13.990000000n
.measure tran d013b6 FIND par('v(dl<6>)-v(dlb<6>)') AT=13.580000000n
.measure tran r013b7 FIND v(dout<7>) AT=13.940000000n
.measure tran s013b7 MIN v(dout<7>) FROM=13.940000000n TO=13.990000000n
.measure tran d013b7 FIND par('v(dl<7>)-v(dlb<7>)') AT=13.580000000n
.measure tran r014b0 FIND v(dout<0>) AT=15.940000000n
.measure tran s014b0 MIN v(dout<0>) FROM=15.940000000n TO=15.990000000n
.measure tran d014b0 FIND par('v(dl<0>)-v(dlb<0>)') AT=15.580000000n
.measure tran r014b1 FIND v(dout<1>) AT=15.940000000n
.measure tran s014b1 MAX v(dout<1>) FROM=15.940000000n TO=15.990000000n
.measure tran d014b1 FIND par('v(dl<1>)-v(dlb<1>)') AT=15.580000000n
.measure tran r014b2 FIND v(dout<2>) AT=15.940000000n
.measure tran s014b2 MIN v(dout<2>) FROM=15.940000000n TO=15.990000000n
.measure tran d014b2 FIND par('v(dl<2>)-v(dlb<2>)') AT=15.580000000n
.measure tran r014b3 FIND v(dout<3>) AT=15.940000000n
.measure tran s014b3 MAX v(dout<3>) FROM=15.940000000n TO=15.990000000n
.measure tran d014b3 FIND par('v(dl<3>)-v(dlb<3>)') AT=15.580000000n
.measure tran r014b4 FIND v(dout<4>) AT=15.940000000n
.measure tran s014b4 MIN v(dout<4>) FROM=15.940000000n TO=15.990000000n
.measure tran d014b4 FIND par('v(dl<4>)-v(dlb<4>)') AT=15.580000000n
.measure tran r014b5 FIND v(dout<5>) AT=15.940000000n
.measure tran s014b5 MAX v(dout<5>) FROM=15.940000000n TO=15.990000000n
.measure tran d014b5 FIND par('v(dl<5>)-v(dlb<5>)') AT=15.580000000n
.measure tran r014b6 FIND v(dout<6>) AT=15.940000000n
.measure tran s014b6 MIN v(dout<6>) FROM=15.940000000n TO=15.990000000n
.measure tran d014b6 FIND par('v(dl<6>)-v(dlb<6>)') AT=15.580000000n
.measure tran r014b7 FIND v(dout<7>) AT=15.940000000n
.measure tran s014b7 MAX v(dout<7>) FROM=15.940000000n TO=15.990000000n
.measure tran d014b7 FIND par('v(dl<7>)-v(dlb<7>)') AT=15.580000000n
.measure tran r015b0 FIND v(dout<0>) AT=17.940000000n
.measure tran s015b0 MAX v(dout<0>) FROM=17.940000000n TO=17.990000000n
.measure tran d015b0 FIND par('v(dl<0>)-v(dlb<0>)') AT=17.580000000n
.measure tran r015b1 FIND v(dout<1>) AT=17.940000000n
.measure tran s015b1 MIN v(dout<1>) FROM=17.940000000n TO=17.990000000n
.measure tran d015b1 FIND par('v(dl<1>)-v(dlb<1>)') AT=17.580000000n
.measure tran r015b2 FIND v(dout<2>) AT=17.940000000n
.measure tran s015b2 MAX v(dout<2>) FROM=17.940000000n TO=17.990000000n
.measure tran d015b2 FIND par('v(dl<2>)-v(dlb<2>)') AT=17.580000000n
.measure tran r015b3 FIND v(dout<3>) AT=17.940000000n
.measure tran s015b3 MIN v(dout<3>) FROM=17.940000000n TO=17.990000000n
.measure tran d015b3 FIND par('v(dl<3>)-v(dlb<3>)') AT=17.580000000n
.measure tran r015b4 FIND v(dout<4>) AT=17.940000000n
.measure tran s015b4 MAX v(dout<4>) FROM=17.940000000n TO=17.990000000n
.measure tran d015b4 FIND par('v(dl<4>)-v(dlb<4>)') AT=17.580000000n
.measure tran r015b5 FIND v(dout<5>) AT=17.940000000n
.measure tran s015b5 MIN v(dout<5>) FROM=17.940000000n TO=17.990000000n
.measure tran d015b5 FIND par('v(dl<5>)-v(dlb<5>)') AT=17.580000000n
.measure tran r015b6 FIND v(dout<6>) AT=17.940000000n
.measure tran s015b6 MAX v(dout<6>) FROM=17.940000000n TO=17.990000000n
.measure tran d015b6 FIND par('v(dl<6>)-v(dlb<6>)') AT=17.580000000n
.measure tran r015b7 FIND v(dout<7>) AT=17.940000000n
.measure tran s015b7 MIN v(dout<7>) FROM=17.940000000n TO=17.990000000n
.measure tran d015b7 FIND par('v(dl<7>)-v(dlb<7>)') AT=17.580000000n
.measure tran w016b0 FIND v(xdut.n_xarray/xi0/xi5/net2_xarray/xi0/xi5/mm0_g) AT=18.630000000n
.measure tran w016b1 FIND v(xdut.n_xarray/xi0/xi9/net2_xarray/xi0/xi9/mm0_g) AT=18.630000000n
.measure tran w016b2 FIND v(xdut.n_xarray/xi0/xi13/net2_xarray/xi0/xi13/mm0_g) AT=18.630000000n
.measure tran w016b3 FIND v(xdut.n_xarray/xi0/xi17/net2_xarray/xi0/xi17/mm0_g) AT=18.630000000n
.measure tran w016b4 FIND v(xdut.n_xarray/xi0/xi21/net2_xarray/xi0/xi21/mm0_g) AT=18.630000000n
.measure tran w016b5 FIND v(xdut.n_xarray/xi0/xi25/net2_xarray/xi0/xi25/mm0_g) AT=18.630000000n
.measure tran w016b6 FIND v(xdut.n_xarray/xi0/xi29/net2_xarray/xi0/xi29/mm0_g) AT=18.630000000n
.measure tran w016b7 FIND v(xdut.n_xarray/xi0/xi33/net2_xarray/xi0/xi33/mm0_g) AT=18.630000000n
.measure tran w017b0 FIND v(xdut.n_xarray/xi0/xi6/net2_xarray/xi0/xi6/mm0_g) AT=20.630000000n
.measure tran w017b1 FIND v(xdut.n_xarray/xi0/xi10/net2_xarray/xi0/xi10/mm0_g) AT=20.630000000n
.measure tran w017b2 FIND v(xdut.n_xarray/xi0/xi14/net2_xarray/xi0/xi14/mm0_g) AT=20.630000000n
.measure tran w017b3 FIND v(xdut.n_xarray/xi0/xi18/net2_xarray/xi0/xi18/mm0_g) AT=20.630000000n
.measure tran w017b4 FIND v(xdut.n_xarray/xi0/xi22/net2_xarray/xi0/xi22/mm0_g) AT=20.630000000n
.measure tran w017b5 FIND v(xdut.n_xarray/xi0/xi26/net2_xarray/xi0/xi26/mm0_g) AT=20.630000000n
.measure tran w017b6 FIND v(xdut.n_xarray/xi0/xi30/net2_xarray/xi0/xi30/mm0_g) AT=20.630000000n
.measure tran w017b7 FIND v(xdut.n_xarray/xi0/xi34/net2_xarray/xi0/xi34/mm0_g) AT=20.630000000n
.measure tran w018b0 FIND v(xdut.n_xarray/xi0/xi7/net2_xarray/xi0/xi7/mm0_g) AT=22.630000000n
.measure tran w018b1 FIND v(xdut.n_xarray/xi0/xi11/net2_xarray/xi0/xi11/mm0_g) AT=22.630000000n
.measure tran w018b2 FIND v(xdut.n_xarray/xi0/xi15/net2_xarray/xi0/xi15/mm0_g) AT=22.630000000n
.measure tran w018b3 FIND v(xdut.n_xarray/xi0/xi19/net2_xarray/xi0/xi19/mm0_g) AT=22.630000000n
.measure tran w018b4 FIND v(xdut.n_xarray/xi0/xi23/net2_xarray/xi0/xi23/mm0_g) AT=22.630000000n
.measure tran w018b5 FIND v(xdut.n_xarray/xi0/xi27/net2_xarray/xi0/xi27/mm0_g) AT=22.630000000n
.measure tran w018b6 FIND v(xdut.n_xarray/xi0/xi31/net2_xarray/xi0/xi31/mm0_g) AT=22.630000000n
.measure tran w018b7 FIND v(xdut.n_xarray/xi0/xi35/net2_xarray/xi0/xi35/mm0_g) AT=22.630000000n
.measure tran w019b0 FIND v(xdut.n_xarray/xi0/xi8/net2_xarray/xi0/xi8/mm0_g) AT=24.630000000n
.measure tran w019b1 FIND v(xdut.n_xarray/xi0/xi12/net2_xarray/xi0/xi12/mm0_g) AT=24.630000000n
.measure tran w019b2 FIND v(xdut.n_xarray/xi0/xi16/net2_xarray/xi0/xi16/mm0_g) AT=24.630000000n
.measure tran w019b3 FIND v(xdut.n_xarray/xi0/xi20/net2_xarray/xi0/xi20/mm0_g) AT=24.630000000n
.measure tran w019b4 FIND v(xdut.n_xarray/xi0/xi24/net2_xarray/xi0/xi24/mm0_g) AT=24.630000000n
.measure tran w019b5 FIND v(xdut.n_xarray/xi0/xi28/net2_xarray/xi0/xi28/mm0_g) AT=24.630000000n
.measure tran w019b6 FIND v(xdut.n_xarray/xi0/xi32/net2_xarray/xi0/xi32/mm0_g) AT=24.630000000n
.measure tran w019b7 FIND v(xdut.n_xarray/xi0/xi36/net2_xarray/xi0/xi36/mm0_g) AT=24.630000000n
.measure tran w020b0 FIND v(xdut.n_xarray/xi15/xi5/net2_xarray/xi15/xi5/mm0_g) AT=26.630000000n
.measure tran w020b1 FIND v(xdut.n_xarray/xi15/xi9/net2_xarray/xi15/xi9/mm0_g) AT=26.630000000n
.measure tran w020b2 FIND v(xdut.n_xarray/xi15/xi13/net2_xarray/xi15/xi13/mm0_g) AT=26.630000000n
.measure tran w020b3 FIND v(xdut.n_xarray/xi15/xi17/net2_xarray/xi15/xi17/mm0_g) AT=26.630000000n
.measure tran w020b4 FIND v(xdut.n_xarray/xi15/xi21/net2_xarray/xi15/xi21/mm0_g) AT=26.630000000n
.measure tran w020b5 FIND v(xdut.n_xarray/xi15/xi25/net2_xarray/xi15/xi25/mm0_g) AT=26.630000000n
.measure tran w020b6 FIND v(xdut.n_xarray/xi15/xi29/net2_xarray/xi15/xi29/mm0_g) AT=26.630000000n
.measure tran w020b7 FIND v(xdut.n_xarray/xi15/xi33/net2_xarray/xi15/xi33/mm0_g) AT=26.630000000n
.measure tran w021b0 FIND v(xdut.n_xarray/xi15/xi6/net2_xarray/xi15/xi6/mm0_g) AT=28.630000000n
.measure tran w021b1 FIND v(xdut.n_xarray/xi15/xi10/net2_xarray/xi15/xi10/mm0_g) AT=28.630000000n
.measure tran w021b2 FIND v(xdut.n_xarray/xi15/xi14/net2_xarray/xi15/xi14/mm0_g) AT=28.630000000n
.measure tran w021b3 FIND v(xdut.n_xarray/xi15/xi18/net2_xarray/xi15/xi18/mm0_g) AT=28.630000000n
.measure tran w021b4 FIND v(xdut.n_xarray/xi15/xi22/net2_xarray/xi15/xi22/mm0_g) AT=28.630000000n
.measure tran w021b5 FIND v(xdut.n_xarray/xi15/xi26/net2_xarray/xi15/xi26/mm0_g) AT=28.630000000n
.measure tran w021b6 FIND v(xdut.n_xarray/xi15/xi30/net2_xarray/xi15/xi30/mm0_g) AT=28.630000000n
.measure tran w021b7 FIND v(xdut.n_xarray/xi15/xi34/net2_xarray/xi15/xi34/mm0_g) AT=28.630000000n
.measure tran w022b0 FIND v(xdut.n_xarray/xi15/xi7/net2_xarray/xi15/xi7/mm0_g) AT=30.630000000n
.measure tran w022b1 FIND v(xdut.n_xarray/xi15/xi11/net2_xarray/xi15/xi11/mm0_g) AT=30.630000000n
.measure tran w022b2 FIND v(xdut.n_xarray/xi15/xi15/net2_xarray/xi15/xi15/mm0_g) AT=30.630000000n
.measure tran w022b3 FIND v(xdut.n_xarray/xi15/xi19/net2_xarray/xi15/xi19/mm0_g) AT=30.630000000n
.measure tran w022b4 FIND v(xdut.n_xarray/xi15/xi23/net2_xarray/xi15/xi23/mm0_g) AT=30.630000000n
.measure tran w022b5 FIND v(xdut.n_xarray/xi15/xi27/net2_xarray/xi15/xi27/mm0_g) AT=30.630000000n
.measure tran w022b6 FIND v(xdut.n_xarray/xi15/xi31/net2_xarray/xi15/xi31/mm0_g) AT=30.630000000n
.measure tran w022b7 FIND v(xdut.n_xarray/xi15/xi35/net2_xarray/xi15/xi35/mm0_g) AT=30.630000000n
.measure tran w023b0 FIND v(xdut.n_xarray/xi15/xi8/net2_xarray/xi15/xi8/mm0_g) AT=32.630000000n
.measure tran w023b1 FIND v(xdut.n_xarray/xi15/xi12/net2_xarray/xi15/xi12/mm0_g) AT=32.630000000n
.measure tran w023b2 FIND v(xdut.n_xarray/xi15/xi16/net2_xarray/xi15/xi16/mm0_g) AT=32.630000000n
.measure tran w023b3 FIND v(xdut.n_xarray/xi15/xi20/net2_xarray/xi15/xi20/mm0_g) AT=32.630000000n
.measure tran w023b4 FIND v(xdut.n_xarray/xi15/xi24/net2_xarray/xi15/xi24/mm0_g) AT=32.630000000n
.measure tran w023b5 FIND v(xdut.n_xarray/xi15/xi28/net2_xarray/xi15/xi28/mm0_g) AT=32.630000000n
.measure tran w023b6 FIND v(xdut.n_xarray/xi15/xi32/net2_xarray/xi15/xi32/mm0_g) AT=32.630000000n
.measure tran w023b7 FIND v(xdut.n_xarray/xi15/xi36/net2_xarray/xi15/xi36/mm0_g) AT=32.630000000n
.measure tran r024b0 FIND v(dout<0>) AT=19.940000000n
.measure tran s024b0 MIN v(dout<0>) FROM=19.940000000n TO=19.990000000n
.measure tran d024b0 FIND par('v(dl<0>)-v(dlb<0>)') AT=19.580000000n
.measure tran r024b1 FIND v(dout<1>) AT=19.940000000n
.measure tran s024b1 MAX v(dout<1>) FROM=19.940000000n TO=19.990000000n
.measure tran d024b1 FIND par('v(dl<1>)-v(dlb<1>)') AT=19.580000000n
.measure tran r024b2 FIND v(dout<2>) AT=19.940000000n
.measure tran s024b2 MIN v(dout<2>) FROM=19.940000000n TO=19.990000000n
.measure tran d024b2 FIND par('v(dl<2>)-v(dlb<2>)') AT=19.580000000n
.measure tran r024b3 FIND v(dout<3>) AT=19.940000000n
.measure tran s024b3 MAX v(dout<3>) FROM=19.940000000n TO=19.990000000n
.measure tran d024b3 FIND par('v(dl<3>)-v(dlb<3>)') AT=19.580000000n
.measure tran r024b4 FIND v(dout<4>) AT=19.940000000n
.measure tran s024b4 MIN v(dout<4>) FROM=19.940000000n TO=19.990000000n
.measure tran d024b4 FIND par('v(dl<4>)-v(dlb<4>)') AT=19.580000000n
.measure tran r024b5 FIND v(dout<5>) AT=19.940000000n
.measure tran s024b5 MAX v(dout<5>) FROM=19.940000000n TO=19.990000000n
.measure tran d024b5 FIND par('v(dl<5>)-v(dlb<5>)') AT=19.580000000n
.measure tran r024b6 FIND v(dout<6>) AT=19.940000000n
.measure tran s024b6 MIN v(dout<6>) FROM=19.940000000n TO=19.990000000n
.measure tran d024b6 FIND par('v(dl<6>)-v(dlb<6>)') AT=19.580000000n
.measure tran r024b7 FIND v(dout<7>) AT=19.940000000n
.measure tran s024b7 MAX v(dout<7>) FROM=19.940000000n TO=19.990000000n
.measure tran d024b7 FIND par('v(dl<7>)-v(dlb<7>)') AT=19.580000000n
.measure tran r025b0 FIND v(dout<0>) AT=21.940000000n
.measure tran s025b0 MAX v(dout<0>) FROM=21.940000000n TO=21.990000000n
.measure tran d025b0 FIND par('v(dl<0>)-v(dlb<0>)') AT=21.580000000n
.measure tran r025b1 FIND v(dout<1>) AT=21.940000000n
.measure tran s025b1 MIN v(dout<1>) FROM=21.940000000n TO=21.990000000n
.measure tran d025b1 FIND par('v(dl<1>)-v(dlb<1>)') AT=21.580000000n
.measure tran r025b2 FIND v(dout<2>) AT=21.940000000n
.measure tran s025b2 MAX v(dout<2>) FROM=21.940000000n TO=21.990000000n
.measure tran d025b2 FIND par('v(dl<2>)-v(dlb<2>)') AT=21.580000000n
.measure tran r025b3 FIND v(dout<3>) AT=21.940000000n
.measure tran s025b3 MIN v(dout<3>) FROM=21.940000000n TO=21.990000000n
.measure tran d025b3 FIND par('v(dl<3>)-v(dlb<3>)') AT=21.580000000n
.measure tran r025b4 FIND v(dout<4>) AT=21.940000000n
.measure tran s025b4 MAX v(dout<4>) FROM=21.940000000n TO=21.990000000n
.measure tran d025b4 FIND par('v(dl<4>)-v(dlb<4>)') AT=21.580000000n
.measure tran r025b5 FIND v(dout<5>) AT=21.940000000n
.measure tran s025b5 MIN v(dout<5>) FROM=21.940000000n TO=21.990000000n
.measure tran d025b5 FIND par('v(dl<5>)-v(dlb<5>)') AT=21.580000000n
.measure tran r025b6 FIND v(dout<6>) AT=21.940000000n
.measure tran s025b6 MAX v(dout<6>) FROM=21.940000000n TO=21.990000000n
.measure tran d025b6 FIND par('v(dl<6>)-v(dlb<6>)') AT=21.580000000n
.measure tran r025b7 FIND v(dout<7>) AT=21.940000000n
.measure tran s025b7 MIN v(dout<7>) FROM=21.940000000n TO=21.990000000n
.measure tran d025b7 FIND par('v(dl<7>)-v(dlb<7>)') AT=21.580000000n
.measure tran r026b0 FIND v(dout<0>) AT=23.940000000n
.measure tran s026b0 MIN v(dout<0>) FROM=23.940000000n TO=23.990000000n
.measure tran d026b0 FIND par('v(dl<0>)-v(dlb<0>)') AT=23.580000000n
.measure tran r026b1 FIND v(dout<1>) AT=23.940000000n
.measure tran s026b1 MAX v(dout<1>) FROM=23.940000000n TO=23.990000000n
.measure tran d026b1 FIND par('v(dl<1>)-v(dlb<1>)') AT=23.580000000n
.measure tran r026b2 FIND v(dout<2>) AT=23.940000000n
.measure tran s026b2 MIN v(dout<2>) FROM=23.940000000n TO=23.990000000n
.measure tran d026b2 FIND par('v(dl<2>)-v(dlb<2>)') AT=23.580000000n
.measure tran r026b3 FIND v(dout<3>) AT=23.940000000n
.measure tran s026b3 MAX v(dout<3>) FROM=23.940000000n TO=23.990000000n
.measure tran d026b3 FIND par('v(dl<3>)-v(dlb<3>)') AT=23.580000000n
.measure tran r026b4 FIND v(dout<4>) AT=23.940000000n
.measure tran s026b4 MIN v(dout<4>) FROM=23.940000000n TO=23.990000000n
.measure tran d026b4 FIND par('v(dl<4>)-v(dlb<4>)') AT=23.580000000n
.measure tran r026b5 FIND v(dout<5>) AT=23.940000000n
.measure tran s026b5 MAX v(dout<5>) FROM=23.940000000n TO=23.990000000n
.measure tran d026b5 FIND par('v(dl<5>)-v(dlb<5>)') AT=23.580000000n
.measure tran r026b6 FIND v(dout<6>) AT=23.940000000n
.measure tran s026b6 MIN v(dout<6>) FROM=23.940000000n TO=23.990000000n
.measure tran d026b6 FIND par('v(dl<6>)-v(dlb<6>)') AT=23.580000000n
.measure tran r026b7 FIND v(dout<7>) AT=23.940000000n
.measure tran s026b7 MAX v(dout<7>) FROM=23.940000000n TO=23.990000000n
.measure tran d026b7 FIND par('v(dl<7>)-v(dlb<7>)') AT=23.580000000n
.measure tran r027b0 FIND v(dout<0>) AT=25.940000000n
.measure tran s027b0 MAX v(dout<0>) FROM=25.940000000n TO=25.990000000n
.measure tran d027b0 FIND par('v(dl<0>)-v(dlb<0>)') AT=25.580000000n
.measure tran r027b1 FIND v(dout<1>) AT=25.940000000n
.measure tran s027b1 MIN v(dout<1>) FROM=25.940000000n TO=25.990000000n
.measure tran d027b1 FIND par('v(dl<1>)-v(dlb<1>)') AT=25.580000000n
.measure tran r027b2 FIND v(dout<2>) AT=25.940000000n
.measure tran s027b2 MAX v(dout<2>) FROM=25.940000000n TO=25.990000000n
.measure tran d027b2 FIND par('v(dl<2>)-v(dlb<2>)') AT=25.580000000n
.measure tran r027b3 FIND v(dout<3>) AT=25.940000000n
.measure tran s027b3 MIN v(dout<3>) FROM=25.940000000n TO=25.990000000n
.measure tran d027b3 FIND par('v(dl<3>)-v(dlb<3>)') AT=25.580000000n
.measure tran r027b4 FIND v(dout<4>) AT=25.940000000n
.measure tran s027b4 MAX v(dout<4>) FROM=25.940000000n TO=25.990000000n
.measure tran d027b4 FIND par('v(dl<4>)-v(dlb<4>)') AT=25.580000000n
.measure tran r027b5 FIND v(dout<5>) AT=25.940000000n
.measure tran s027b5 MIN v(dout<5>) FROM=25.940000000n TO=25.990000000n
.measure tran d027b5 FIND par('v(dl<5>)-v(dlb<5>)') AT=25.580000000n
.measure tran r027b6 FIND v(dout<6>) AT=25.940000000n
.measure tran s027b6 MAX v(dout<6>) FROM=25.940000000n TO=25.990000000n
.measure tran d027b6 FIND par('v(dl<6>)-v(dlb<6>)') AT=25.580000000n
.measure tran r027b7 FIND v(dout<7>) AT=25.940000000n
.measure tran s027b7 MIN v(dout<7>) FROM=25.940000000n TO=25.990000000n
.measure tran d027b7 FIND par('v(dl<7>)-v(dlb<7>)') AT=25.580000000n
.measure tran r028b0 FIND v(dout<0>) AT=27.940000000n
.measure tran s028b0 MAX v(dout<0>) FROM=27.940000000n TO=27.990000000n
.measure tran d028b0 FIND par('v(dl<0>)-v(dlb<0>)') AT=27.580000000n
.measure tran r028b1 FIND v(dout<1>) AT=27.940000000n
.measure tran s028b1 MIN v(dout<1>) FROM=27.940000000n TO=27.990000000n
.measure tran d028b1 FIND par('v(dl<1>)-v(dlb<1>)') AT=27.580000000n
.measure tran r028b2 FIND v(dout<2>) AT=27.940000000n
.measure tran s028b2 MAX v(dout<2>) FROM=27.940000000n TO=27.990000000n
.measure tran d028b2 FIND par('v(dl<2>)-v(dlb<2>)') AT=27.580000000n
.measure tran r028b3 FIND v(dout<3>) AT=27.940000000n
.measure tran s028b3 MIN v(dout<3>) FROM=27.940000000n TO=27.990000000n
.measure tran d028b3 FIND par('v(dl<3>)-v(dlb<3>)') AT=27.580000000n
.measure tran r028b4 FIND v(dout<4>) AT=27.940000000n
.measure tran s028b4 MAX v(dout<4>) FROM=27.940000000n TO=27.990000000n
.measure tran d028b4 FIND par('v(dl<4>)-v(dlb<4>)') AT=27.580000000n
.measure tran r028b5 FIND v(dout<5>) AT=27.940000000n
.measure tran s028b5 MIN v(dout<5>) FROM=27.940000000n TO=27.990000000n
.measure tran d028b5 FIND par('v(dl<5>)-v(dlb<5>)') AT=27.580000000n
.measure tran r028b6 FIND v(dout<6>) AT=27.940000000n
.measure tran s028b6 MAX v(dout<6>) FROM=27.940000000n TO=27.990000000n
.measure tran d028b6 FIND par('v(dl<6>)-v(dlb<6>)') AT=27.580000000n
.measure tran r028b7 FIND v(dout<7>) AT=27.940000000n
.measure tran s028b7 MIN v(dout<7>) FROM=27.940000000n TO=27.990000000n
.measure tran d028b7 FIND par('v(dl<7>)-v(dlb<7>)') AT=27.580000000n
.measure tran r029b0 FIND v(dout<0>) AT=29.940000000n
.measure tran s029b0 MIN v(dout<0>) FROM=29.940000000n TO=29.990000000n
.measure tran d029b0 FIND par('v(dl<0>)-v(dlb<0>)') AT=29.580000000n
.measure tran r029b1 FIND v(dout<1>) AT=29.940000000n
.measure tran s029b1 MAX v(dout<1>) FROM=29.940000000n TO=29.990000000n
.measure tran d029b1 FIND par('v(dl<1>)-v(dlb<1>)') AT=29.580000000n
.measure tran r029b2 FIND v(dout<2>) AT=29.940000000n
.measure tran s029b2 MIN v(dout<2>) FROM=29.940000000n TO=29.990000000n
.measure tran d029b2 FIND par('v(dl<2>)-v(dlb<2>)') AT=29.580000000n
.measure tran r029b3 FIND v(dout<3>) AT=29.940000000n
.measure tran s029b3 MAX v(dout<3>) FROM=29.940000000n TO=29.990000000n
.measure tran d029b3 FIND par('v(dl<3>)-v(dlb<3>)') AT=29.580000000n
.measure tran r029b4 FIND v(dout<4>) AT=29.940000000n
.measure tran s029b4 MIN v(dout<4>) FROM=29.940000000n TO=29.990000000n
.measure tran d029b4 FIND par('v(dl<4>)-v(dlb<4>)') AT=29.580000000n
.measure tran r029b5 FIND v(dout<5>) AT=29.940000000n
.measure tran s029b5 MAX v(dout<5>) FROM=29.940000000n TO=29.990000000n
.measure tran d029b5 FIND par('v(dl<5>)-v(dlb<5>)') AT=29.580000000n
.measure tran r029b6 FIND v(dout<6>) AT=29.940000000n
.measure tran s029b6 MIN v(dout<6>) FROM=29.940000000n TO=29.990000000n
.measure tran d029b6 FIND par('v(dl<6>)-v(dlb<6>)') AT=29.580000000n
.measure tran r029b7 FIND v(dout<7>) AT=29.940000000n
.measure tran s029b7 MAX v(dout<7>) FROM=29.940000000n TO=29.990000000n
.measure tran d029b7 FIND par('v(dl<7>)-v(dlb<7>)') AT=29.580000000n
.measure tran r030b0 FIND v(dout<0>) AT=31.940000000n
.measure tran s030b0 MAX v(dout<0>) FROM=31.940000000n TO=31.990000000n
.measure tran d030b0 FIND par('v(dl<0>)-v(dlb<0>)') AT=31.580000000n
.measure tran r030b1 FIND v(dout<1>) AT=31.940000000n
.measure tran s030b1 MIN v(dout<1>) FROM=31.940000000n TO=31.990000000n
.measure tran d030b1 FIND par('v(dl<1>)-v(dlb<1>)') AT=31.580000000n
.measure tran r030b2 FIND v(dout<2>) AT=31.940000000n
.measure tran s030b2 MAX v(dout<2>) FROM=31.940000000n TO=31.990000000n
.measure tran d030b2 FIND par('v(dl<2>)-v(dlb<2>)') AT=31.580000000n
.measure tran r030b3 FIND v(dout<3>) AT=31.940000000n
.measure tran s030b3 MIN v(dout<3>) FROM=31.940000000n TO=31.990000000n
.measure tran d030b3 FIND par('v(dl<3>)-v(dlb<3>)') AT=31.580000000n
.measure tran r030b4 FIND v(dout<4>) AT=31.940000000n
.measure tran s030b4 MAX v(dout<4>) FROM=31.940000000n TO=31.990000000n
.measure tran d030b4 FIND par('v(dl<4>)-v(dlb<4>)') AT=31.580000000n
.measure tran r030b5 FIND v(dout<5>) AT=31.940000000n
.measure tran s030b5 MIN v(dout<5>) FROM=31.940000000n TO=31.990000000n
.measure tran d030b5 FIND par('v(dl<5>)-v(dlb<5>)') AT=31.580000000n
.measure tran r030b6 FIND v(dout<6>) AT=31.940000000n
.measure tran s030b6 MAX v(dout<6>) FROM=31.940000000n TO=31.990000000n
.measure tran d030b6 FIND par('v(dl<6>)-v(dlb<6>)') AT=31.580000000n
.measure tran r030b7 FIND v(dout<7>) AT=31.940000000n
.measure tran s030b7 MIN v(dout<7>) FROM=31.940000000n TO=31.990000000n
.measure tran d030b7 FIND par('v(dl<7>)-v(dlb<7>)') AT=31.580000000n
.measure tran r031b0 FIND v(dout<0>) AT=33.940000000n
.measure tran s031b0 MIN v(dout<0>) FROM=33.940000000n TO=33.990000000n
.measure tran d031b0 FIND par('v(dl<0>)-v(dlb<0>)') AT=33.580000000n
.measure tran r031b1 FIND v(dout<1>) AT=33.940000000n
.measure tran s031b1 MAX v(dout<1>) FROM=33.940000000n TO=33.990000000n
.measure tran d031b1 FIND par('v(dl<1>)-v(dlb<1>)') AT=33.580000000n
.measure tran r031b2 FIND v(dout<2>) AT=33.940000000n
.measure tran s031b2 MIN v(dout<2>) FROM=33.940000000n TO=33.990000000n
.measure tran d031b2 FIND par('v(dl<2>)-v(dlb<2>)') AT=33.580000000n
.measure tran r031b3 FIND v(dout<3>) AT=33.940000000n
.measure tran s031b3 MAX v(dout<3>) FROM=33.940000000n TO=33.990000000n
.measure tran d031b3 FIND par('v(dl<3>)-v(dlb<3>)') AT=33.580000000n
.measure tran r031b4 FIND v(dout<4>) AT=33.940000000n
.measure tran s031b4 MIN v(dout<4>) FROM=33.940000000n TO=33.990000000n
.measure tran d031b4 FIND par('v(dl<4>)-v(dlb<4>)') AT=33.580000000n
.measure tran r031b5 FIND v(dout<5>) AT=33.940000000n
.measure tran s031b5 MAX v(dout<5>) FROM=33.940000000n TO=33.990000000n
.measure tran d031b5 FIND par('v(dl<5>)-v(dlb<5>)') AT=33.580000000n
.measure tran r031b6 FIND v(dout<6>) AT=33.940000000n
.measure tran s031b6 MIN v(dout<6>) FROM=33.940000000n TO=33.990000000n
.measure tran d031b6 FIND par('v(dl<6>)-v(dlb<6>)') AT=33.580000000n
.measure tran r031b7 FIND v(dout<7>) AT=33.940000000n
.measure tran s031b7 MAX v(dout<7>) FROM=33.940000000n TO=33.990000000n
.measure tran d031b7 FIND par('v(dl<7>)-v(dlb<7>)') AT=33.580000000n
.measure tran f00c00 FIND v(xdut.n_xarray/xi0/xi5/net2_xarray/xi0/xi5/mm0_g) AT=34.900000000n
.measure tran f00c01 FIND v(xdut.n_xarray/xi0/xi9/net2_xarray/xi0/xi9/mm0_g) AT=34.900000000n
.measure tran f00c02 FIND v(xdut.n_xarray/xi0/xi13/net2_xarray/xi0/xi13/mm0_g) AT=34.900000000n
.measure tran f00c03 FIND v(xdut.n_xarray/xi0/xi17/net2_xarray/xi0/xi17/mm0_g) AT=34.900000000n
.measure tran f00c04 FIND v(xdut.n_xarray/xi0/xi21/net2_xarray/xi0/xi21/mm0_g) AT=34.900000000n
.measure tran f00c05 FIND v(xdut.n_xarray/xi0/xi25/net2_xarray/xi0/xi25/mm0_g) AT=34.900000000n
.measure tran f00c06 FIND v(xdut.n_xarray/xi0/xi29/net2_xarray/xi0/xi29/mm0_g) AT=34.900000000n
.measure tran f00c07 FIND v(xdut.n_xarray/xi0/xi33/net2_xarray/xi0/xi33/mm0_g) AT=34.900000000n
.measure tran f00c08 FIND v(xdut.n_xarray/xi0/xi6/net2_xarray/xi0/xi6/mm0_g) AT=34.900000000n
.measure tran f00c09 FIND v(xdut.n_xarray/xi0/xi10/net2_xarray/xi0/xi10/mm0_g) AT=34.900000000n
.measure tran f00c10 FIND v(xdut.n_xarray/xi0/xi14/net2_xarray/xi0/xi14/mm0_g) AT=34.900000000n
.measure tran f00c11 FIND v(xdut.n_xarray/xi0/xi18/net2_xarray/xi0/xi18/mm0_g) AT=34.900000000n
.measure tran f00c12 FIND v(xdut.n_xarray/xi0/xi22/net2_xarray/xi0/xi22/mm0_g) AT=34.900000000n
.measure tran f00c13 FIND v(xdut.n_xarray/xi0/xi26/net2_xarray/xi0/xi26/mm0_g) AT=34.900000000n
.measure tran f00c14 FIND v(xdut.n_xarray/xi0/xi30/net2_xarray/xi0/xi30/mm0_g) AT=34.900000000n
.measure tran f00c15 FIND v(xdut.n_xarray/xi0/xi34/net2_xarray/xi0/xi34/mm0_g) AT=34.900000000n
.measure tran f00c16 FIND v(xdut.n_xarray/xi0/xi7/net2_xarray/xi0/xi7/mm0_g) AT=34.900000000n
.measure tran f00c17 FIND v(xdut.n_xarray/xi0/xi11/net2_xarray/xi0/xi11/mm0_g) AT=34.900000000n
.measure tran f00c18 FIND v(xdut.n_xarray/xi0/xi15/net2_xarray/xi0/xi15/mm0_g) AT=34.900000000n
.measure tran f00c19 FIND v(xdut.n_xarray/xi0/xi19/net2_xarray/xi0/xi19/mm0_g) AT=34.900000000n
.measure tran f00c20 FIND v(xdut.n_xarray/xi0/xi23/net2_xarray/xi0/xi23/mm0_g) AT=34.900000000n
.measure tran f00c21 FIND v(xdut.n_xarray/xi0/xi27/net2_xarray/xi0/xi27/mm0_g) AT=34.900000000n
.measure tran f00c22 FIND v(xdut.n_xarray/xi0/xi31/net2_xarray/xi0/xi31/mm0_g) AT=34.900000000n
.measure tran f00c23 FIND v(xdut.n_xarray/xi0/xi35/net2_xarray/xi0/xi35/mm0_g) AT=34.900000000n
.measure tran f00c24 FIND v(xdut.n_xarray/xi0/xi8/net2_xarray/xi0/xi8/mm0_g) AT=34.900000000n
.measure tran f00c25 FIND v(xdut.n_xarray/xi0/xi12/net2_xarray/xi0/xi12/mm0_g) AT=34.900000000n
.measure tran f00c26 FIND v(xdut.n_xarray/xi0/xi16/net2_xarray/xi0/xi16/mm0_g) AT=34.900000000n
.measure tran f00c27 FIND v(xdut.n_xarray/xi0/xi20/net2_xarray/xi0/xi20/mm0_g) AT=34.900000000n
.measure tran f00c28 FIND v(xdut.n_xarray/xi0/xi24/net2_xarray/xi0/xi24/mm0_g) AT=34.900000000n
.measure tran f00c29 FIND v(xdut.n_xarray/xi0/xi28/net2_xarray/xi0/xi28/mm0_g) AT=34.900000000n
.measure tran f00c30 FIND v(xdut.n_xarray/xi0/xi32/net2_xarray/xi0/xi32/mm0_g) AT=34.900000000n
.measure tran f00c31 FIND v(xdut.n_xarray/xi0/xi36/net2_xarray/xi0/xi36/mm0_g) AT=34.900000000n
.measure tran f01c00 FIND v(xdut.n_xarray/xi1/xi5/net2_xarray/xi1/xi5/mm0_g) AT=34.900000000n
.measure tran f01c01 FIND v(xdut.n_xarray/xi1/xi9/net2_xarray/xi1/xi9/mm0_g) AT=34.900000000n
.measure tran f01c02 FIND v(xdut.n_xarray/xi1/xi13/net2_xarray/xi1/xi13/mm0_g) AT=34.900000000n
.measure tran f01c03 FIND v(xdut.n_xarray/xi1/xi17/net2_xarray/xi1/xi17/mm0_g) AT=34.900000000n
.measure tran f01c04 FIND v(xdut.n_xarray/xi1/xi21/net2_xarray/xi1/xi21/mm0_g) AT=34.900000000n
.measure tran f01c05 FIND v(xdut.n_xarray/xi1/xi25/net2_xarray/xi1/xi25/mm0_g) AT=34.900000000n
.measure tran f01c06 FIND v(xdut.n_xarray/xi1/xi29/net2_xarray/xi1/xi29/mm0_g) AT=34.900000000n
.measure tran f01c07 FIND v(xdut.n_xarray/xi1/xi33/net2_xarray/xi1/xi33/mm0_g) AT=34.900000000n
.measure tran f01c08 FIND v(xdut.n_xarray/xi1/xi6/net2_xarray/xi1/xi6/mm0_g) AT=34.900000000n
.measure tran f01c09 FIND v(xdut.n_xarray/xi1/xi10/net2_xarray/xi1/xi10/mm0_g) AT=34.900000000n
.measure tran f01c10 FIND v(xdut.n_xarray/xi1/xi14/net2_xarray/xi1/xi14/mm0_g) AT=34.900000000n
.measure tran f01c11 FIND v(xdut.n_xarray/xi1/xi18/net2_xarray/xi1/xi18/mm0_g) AT=34.900000000n
.measure tran f01c12 FIND v(xdut.n_xarray/xi1/xi22/net2_xarray/xi1/xi22/mm0_g) AT=34.900000000n
.measure tran f01c13 FIND v(xdut.n_xarray/xi1/xi26/net2_xarray/xi1/xi26/mm0_g) AT=34.900000000n
.measure tran f01c14 FIND v(xdut.n_xarray/xi1/xi30/net2_xarray/xi1/xi30/mm0_g) AT=34.900000000n
.measure tran f01c15 FIND v(xdut.n_xarray/xi1/xi34/net2_xarray/xi1/xi34/mm0_g) AT=34.900000000n
.measure tran f01c16 FIND v(xdut.n_xarray/xi1/xi7/net2_xarray/xi1/xi7/mm0_g) AT=34.900000000n
.measure tran f01c17 FIND v(xdut.n_xarray/xi1/xi11/net2_xarray/xi1/xi11/mm0_g) AT=34.900000000n
.measure tran f01c18 FIND v(xdut.n_xarray/xi1/xi15/net2_xarray/xi1/xi15/mm0_g) AT=34.900000000n
.measure tran f01c19 FIND v(xdut.n_xarray/xi1/xi19/net2_xarray/xi1/xi19/mm0_g) AT=34.900000000n
.measure tran f01c20 FIND v(xdut.n_xarray/xi1/xi23/net2_xarray/xi1/xi23/mm0_g) AT=34.900000000n
.measure tran f01c21 FIND v(xdut.n_xarray/xi1/xi27/net2_xarray/xi1/xi27/mm0_g) AT=34.900000000n
.measure tran f01c22 FIND v(xdut.n_xarray/xi1/xi31/net2_xarray/xi1/xi31/mm0_g) AT=34.900000000n
.measure tran f01c23 FIND v(xdut.n_xarray/xi1/xi35/net2_xarray/xi1/xi35/mm0_g) AT=34.900000000n
.measure tran f01c24 FIND v(xdut.n_xarray/xi1/xi8/net2_xarray/xi1/xi8/mm0_g) AT=34.900000000n
.measure tran f01c25 FIND v(xdut.n_xarray/xi1/xi12/net2_xarray/xi1/xi12/mm0_g) AT=34.900000000n
.measure tran f01c26 FIND v(xdut.n_xarray/xi1/xi16/net2_xarray/xi1/xi16/mm0_g) AT=34.900000000n
.measure tran f01c27 FIND v(xdut.n_xarray/xi1/xi20/net2_xarray/xi1/xi20/mm0_g) AT=34.900000000n
.measure tran f01c28 FIND v(xdut.n_xarray/xi1/xi24/net2_xarray/xi1/xi24/mm0_g) AT=34.900000000n
.measure tran f01c29 FIND v(xdut.n_xarray/xi1/xi28/net2_xarray/xi1/xi28/mm0_g) AT=34.900000000n
.measure tran f01c30 FIND v(xdut.n_xarray/xi1/xi32/net2_xarray/xi1/xi32/mm0_g) AT=34.900000000n
.measure tran f01c31 FIND v(xdut.n_xarray/xi1/xi36/net2_xarray/xi1/xi36/mm0_g) AT=34.900000000n
.measure tran f02c00 FIND v(xdut.n_xarray/xi2/xi5/net2_xarray/xi2/xi5/mm0_g) AT=34.900000000n
.measure tran f02c01 FIND v(xdut.n_xarray/xi2/xi9/net2_xarray/xi2/xi9/mm0_g) AT=34.900000000n
.measure tran f02c02 FIND v(xdut.n_xarray/xi2/xi13/net2_xarray/xi2/xi13/mm0_g) AT=34.900000000n
.measure tran f02c03 FIND v(xdut.n_xarray/xi2/xi17/net2_xarray/xi2/xi17/mm0_g) AT=34.900000000n
.measure tran f02c04 FIND v(xdut.n_xarray/xi2/xi21/net2_xarray/xi2/xi21/mm0_g) AT=34.900000000n
.measure tran f02c05 FIND v(xdut.n_xarray/xi2/xi25/net2_xarray/xi2/xi25/mm0_g) AT=34.900000000n
.measure tran f02c06 FIND v(xdut.n_xarray/xi2/xi29/net2_xarray/xi2/xi29/mm0_g) AT=34.900000000n
.measure tran f02c07 FIND v(xdut.n_xarray/xi2/xi33/net2_xarray/xi2/xi33/mm0_g) AT=34.900000000n
.measure tran f02c08 FIND v(xdut.n_xarray/xi2/xi6/net2_xarray/xi2/xi6/mm0_g) AT=34.900000000n
.measure tran f02c09 FIND v(xdut.n_xarray/xi2/xi10/net2_xarray/xi2/xi10/mm0_g) AT=34.900000000n
.measure tran f02c10 FIND v(xdut.n_xarray/xi2/xi14/net2_xarray/xi2/xi14/mm0_g) AT=34.900000000n
.measure tran f02c11 FIND v(xdut.n_xarray/xi2/xi18/net2_xarray/xi2/xi18/mm0_g) AT=34.900000000n
.measure tran f02c12 FIND v(xdut.n_xarray/xi2/xi22/net2_xarray/xi2/xi22/mm0_g) AT=34.900000000n
.measure tran f02c13 FIND v(xdut.n_xarray/xi2/xi26/net2_xarray/xi2/xi26/mm0_g) AT=34.900000000n
.measure tran f02c14 FIND v(xdut.n_xarray/xi2/xi30/net2_xarray/xi2/xi30/mm0_g) AT=34.900000000n
.measure tran f02c15 FIND v(xdut.n_xarray/xi2/xi34/net2_xarray/xi2/xi34/mm0_g) AT=34.900000000n
.measure tran f02c16 FIND v(xdut.n_xarray/xi2/xi7/net2_xarray/xi2/xi7/mm0_g) AT=34.900000000n
.measure tran f02c17 FIND v(xdut.n_xarray/xi2/xi11/net2_xarray/xi2/xi11/mm0_g) AT=34.900000000n
.measure tran f02c18 FIND v(xdut.n_xarray/xi2/xi15/net2_xarray/xi2/xi15/mm0_g) AT=34.900000000n
.measure tran f02c19 FIND v(xdut.n_xarray/xi2/xi19/net2_xarray/xi2/xi19/mm0_g) AT=34.900000000n
.measure tran f02c20 FIND v(xdut.n_xarray/xi2/xi23/net2_xarray/xi2/xi23/mm0_g) AT=34.900000000n
.measure tran f02c21 FIND v(xdut.n_xarray/xi2/xi27/net2_xarray/xi2/xi27/mm0_g) AT=34.900000000n
.measure tran f02c22 FIND v(xdut.n_xarray/xi2/xi31/net2_xarray/xi2/xi31/mm0_g) AT=34.900000000n
.measure tran f02c23 FIND v(xdut.n_xarray/xi2/xi35/net2_xarray/xi2/xi35/mm0_g) AT=34.900000000n
.measure tran f02c24 FIND v(xdut.n_xarray/xi2/xi8/net2_xarray/xi2/xi8/mm0_g) AT=34.900000000n
.measure tran f02c25 FIND v(xdut.n_xarray/xi2/xi12/net2_xarray/xi2/xi12/mm0_g) AT=34.900000000n
.measure tran f02c26 FIND v(xdut.n_xarray/xi2/xi16/net2_xarray/xi2/xi16/mm0_g) AT=34.900000000n
.measure tran f02c27 FIND v(xdut.n_xarray/xi2/xi20/net2_xarray/xi2/xi20/mm0_g) AT=34.900000000n
.measure tran f02c28 FIND v(xdut.n_xarray/xi2/xi24/net2_xarray/xi2/xi24/mm0_g) AT=34.900000000n
.measure tran f02c29 FIND v(xdut.n_xarray/xi2/xi28/net2_xarray/xi2/xi28/mm0_g) AT=34.900000000n
.measure tran f02c30 FIND v(xdut.n_xarray/xi2/xi32/net2_xarray/xi2/xi32/mm0_g) AT=34.900000000n
.measure tran f02c31 FIND v(xdut.n_xarray/xi2/xi36/net2_xarray/xi2/xi36/mm0_g) AT=34.900000000n
.measure tran f03c00 FIND v(xdut.n_xarray/xi3/xi5/net2_xarray/xi3/xi5/mm0_g) AT=34.900000000n
.measure tran f03c01 FIND v(xdut.n_xarray/xi3/xi9/net2_xarray/xi3/xi9/mm0_g) AT=34.900000000n
.measure tran f03c02 FIND v(xdut.n_xarray/xi3/xi13/net2_xarray/xi3/xi13/mm0_g) AT=34.900000000n
.measure tran f03c03 FIND v(xdut.n_xarray/xi3/xi17/net2_xarray/xi3/xi17/mm0_g) AT=34.900000000n
.measure tran f03c04 FIND v(xdut.n_xarray/xi3/xi21/net2_xarray/xi3/xi21/mm0_g) AT=34.900000000n
.measure tran f03c05 FIND v(xdut.n_xarray/xi3/xi25/net2_xarray/xi3/xi25/mm0_g) AT=34.900000000n
.measure tran f03c06 FIND v(xdut.n_xarray/xi3/xi29/net2_xarray/xi3/xi29/mm0_g) AT=34.900000000n
.measure tran f03c07 FIND v(xdut.n_xarray/xi3/xi33/net2_xarray/xi3/xi33/mm0_g) AT=34.900000000n
.measure tran f03c08 FIND v(xdut.n_xarray/xi3/xi6/net2_xarray/xi3/xi6/mm0_g) AT=34.900000000n
.measure tran f03c09 FIND v(xdut.n_xarray/xi3/xi10/net2_xarray/xi3/xi10/mm0_g) AT=34.900000000n
.measure tran f03c10 FIND v(xdut.n_xarray/xi3/xi14/net2_xarray/xi3/xi14/mm0_g) AT=34.900000000n
.measure tran f03c11 FIND v(xdut.n_xarray/xi3/xi18/net2_xarray/xi3/xi18/mm0_g) AT=34.900000000n
.measure tran f03c12 FIND v(xdut.n_xarray/xi3/xi22/net2_xarray/xi3/xi22/mm0_g) AT=34.900000000n
.measure tran f03c13 FIND v(xdut.n_xarray/xi3/xi26/net2_xarray/xi3/xi26/mm0_g) AT=34.900000000n
.measure tran f03c14 FIND v(xdut.n_xarray/xi3/xi30/net2_xarray/xi3/xi30/mm0_g) AT=34.900000000n
.measure tran f03c15 FIND v(xdut.n_xarray/xi3/xi34/net2_xarray/xi3/xi34/mm0_g) AT=34.900000000n
.measure tran f03c16 FIND v(xdut.n_xarray/xi3/xi7/net2_xarray/xi3/xi7/mm0_g) AT=34.900000000n
.measure tran f03c17 FIND v(xdut.n_xarray/xi3/xi11/net2_xarray/xi3/xi11/mm0_g) AT=34.900000000n
.measure tran f03c18 FIND v(xdut.n_xarray/xi3/xi15/net2_xarray/xi3/xi15/mm0_g) AT=34.900000000n
.measure tran f03c19 FIND v(xdut.n_xarray/xi3/xi19/net2_xarray/xi3/xi19/mm0_g) AT=34.900000000n
.measure tran f03c20 FIND v(xdut.n_xarray/xi3/xi23/net2_xarray/xi3/xi23/mm0_g) AT=34.900000000n
.measure tran f03c21 FIND v(xdut.n_xarray/xi3/xi27/net2_xarray/xi3/xi27/mm0_g) AT=34.900000000n
.measure tran f03c22 FIND v(xdut.n_xarray/xi3/xi31/net2_xarray/xi3/xi31/mm0_g) AT=34.900000000n
.measure tran f03c23 FIND v(xdut.n_xarray/xi3/xi35/net2_xarray/xi3/xi35/mm0_g) AT=34.900000000n
.measure tran f03c24 FIND v(xdut.n_xarray/xi3/xi8/net2_xarray/xi3/xi8/mm0_g) AT=34.900000000n
.measure tran f03c25 FIND v(xdut.n_xarray/xi3/xi12/net2_xarray/xi3/xi12/mm0_g) AT=34.900000000n
.measure tran f03c26 FIND v(xdut.n_xarray/xi3/xi16/net2_xarray/xi3/xi16/mm0_g) AT=34.900000000n
.measure tran f03c27 FIND v(xdut.n_xarray/xi3/xi20/net2_xarray/xi3/xi20/mm0_g) AT=34.900000000n
.measure tran f03c28 FIND v(xdut.n_xarray/xi3/xi24/net2_xarray/xi3/xi24/mm0_g) AT=34.900000000n
.measure tran f03c29 FIND v(xdut.n_xarray/xi3/xi28/net2_xarray/xi3/xi28/mm0_g) AT=34.900000000n
.measure tran f03c30 FIND v(xdut.n_xarray/xi3/xi32/net2_xarray/xi3/xi32/mm0_g) AT=34.900000000n
.measure tran f03c31 FIND v(xdut.n_xarray/xi3/xi36/net2_xarray/xi3/xi36/mm0_g) AT=34.900000000n
.measure tran f04c00 FIND v(xdut.n_xarray/xi4/xi5/net2_xarray/xi4/xi5/mm0_g) AT=34.900000000n
.measure tran f04c01 FIND v(xdut.n_xarray/xi4/xi9/net2_xarray/xi4/xi9/mm0_g) AT=34.900000000n
.measure tran f04c02 FIND v(xdut.n_xarray/xi4/xi13/net2_xarray/xi4/xi13/mm0_g) AT=34.900000000n
.measure tran f04c03 FIND v(xdut.n_xarray/xi4/xi17/net2_xarray/xi4/xi17/mm0_g) AT=34.900000000n
.measure tran f04c04 FIND v(xdut.n_xarray/xi4/xi21/net2_xarray/xi4/xi21/mm0_g) AT=34.900000000n
.measure tran f04c05 FIND v(xdut.n_xarray/xi4/xi25/net2_xarray/xi4/xi25/mm0_g) AT=34.900000000n
.measure tran f04c06 FIND v(xdut.n_xarray/xi4/xi29/net2_xarray/xi4/xi29/mm0_g) AT=34.900000000n
.measure tran f04c07 FIND v(xdut.n_xarray/xi4/xi33/net2_xarray/xi4/xi33/mm0_g) AT=34.900000000n
.measure tran f04c08 FIND v(xdut.n_xarray/xi4/xi6/net2_xarray/xi4/xi6/mm0_g) AT=34.900000000n
.measure tran f04c09 FIND v(xdut.n_xarray/xi4/xi10/net2_xarray/xi4/xi10/mm0_g) AT=34.900000000n
.measure tran f04c10 FIND v(xdut.n_xarray/xi4/xi14/net2_xarray/xi4/xi14/mm0_g) AT=34.900000000n
.measure tran f04c11 FIND v(xdut.n_xarray/xi4/xi18/net2_xarray/xi4/xi18/mm0_g) AT=34.900000000n
.measure tran f04c12 FIND v(xdut.n_xarray/xi4/xi22/net2_xarray/xi4/xi22/mm0_g) AT=34.900000000n
.measure tran f04c13 FIND v(xdut.n_xarray/xi4/xi26/net2_xarray/xi4/xi26/mm0_g) AT=34.900000000n
.measure tran f04c14 FIND v(xdut.n_xarray/xi4/xi30/net2_xarray/xi4/xi30/mm0_g) AT=34.900000000n
.measure tran f04c15 FIND v(xdut.n_xarray/xi4/xi34/net2_xarray/xi4/xi34/mm0_g) AT=34.900000000n
.measure tran f04c16 FIND v(xdut.n_xarray/xi4/xi7/net2_xarray/xi4/xi7/mm0_g) AT=34.900000000n
.measure tran f04c17 FIND v(xdut.n_xarray/xi4/xi11/net2_xarray/xi4/xi11/mm0_g) AT=34.900000000n
.measure tran f04c18 FIND v(xdut.n_xarray/xi4/xi15/net2_xarray/xi4/xi15/mm0_g) AT=34.900000000n
.measure tran f04c19 FIND v(xdut.n_xarray/xi4/xi19/net2_xarray/xi4/xi19/mm0_g) AT=34.900000000n
.measure tran f04c20 FIND v(xdut.n_xarray/xi4/xi23/net2_xarray/xi4/xi23/mm0_g) AT=34.900000000n
.measure tran f04c21 FIND v(xdut.n_xarray/xi4/xi27/net2_xarray/xi4/xi27/mm0_g) AT=34.900000000n
.measure tran f04c22 FIND v(xdut.n_xarray/xi4/xi31/net2_xarray/xi4/xi31/mm0_g) AT=34.900000000n
.measure tran f04c23 FIND v(xdut.n_xarray/xi4/xi35/net2_xarray/xi4/xi35/mm0_g) AT=34.900000000n
.measure tran f04c24 FIND v(xdut.n_xarray/xi4/xi8/net2_xarray/xi4/xi8/mm0_g) AT=34.900000000n
.measure tran f04c25 FIND v(xdut.n_xarray/xi4/xi12/net2_xarray/xi4/xi12/mm0_g) AT=34.900000000n
.measure tran f04c26 FIND v(xdut.n_xarray/xi4/xi16/net2_xarray/xi4/xi16/mm0_g) AT=34.900000000n
.measure tran f04c27 FIND v(xdut.n_xarray/xi4/xi20/net2_xarray/xi4/xi20/mm0_g) AT=34.900000000n
.measure tran f04c28 FIND v(xdut.n_xarray/xi4/xi24/net2_xarray/xi4/xi24/mm0_g) AT=34.900000000n
.measure tran f04c29 FIND v(xdut.n_xarray/xi4/xi28/net2_xarray/xi4/xi28/mm0_g) AT=34.900000000n
.measure tran f04c30 FIND v(xdut.n_xarray/xi4/xi32/net2_xarray/xi4/xi32/mm0_g) AT=34.900000000n
.measure tran f04c31 FIND v(xdut.n_xarray/xi4/xi36/net2_xarray/xi4/xi36/mm0_g) AT=34.900000000n
.measure tran f05c00 FIND v(xdut.n_xarray/xi5/xi5/net2_xarray/xi5/xi5/mm0_g) AT=34.900000000n
.measure tran f05c01 FIND v(xdut.n_xarray/xi5/xi9/net2_xarray/xi5/xi9/mm0_g) AT=34.900000000n
.measure tran f05c02 FIND v(xdut.n_xarray/xi5/xi13/net2_xarray/xi5/xi13/mm0_g) AT=34.900000000n
.measure tran f05c03 FIND v(xdut.n_xarray/xi5/xi17/net2_xarray/xi5/xi17/mm0_g) AT=34.900000000n
.measure tran f05c04 FIND v(xdut.n_xarray/xi5/xi21/net2_xarray/xi5/xi21/mm0_g) AT=34.900000000n
.measure tran f05c05 FIND v(xdut.n_xarray/xi5/xi25/net2_xarray/xi5/xi25/mm0_g) AT=34.900000000n
.measure tran f05c06 FIND v(xdut.n_xarray/xi5/xi29/net2_xarray/xi5/xi29/mm0_g) AT=34.900000000n
.measure tran f05c07 FIND v(xdut.n_xarray/xi5/xi33/net2_xarray/xi5/xi33/mm0_g) AT=34.900000000n
.measure tran f05c08 FIND v(xdut.n_xarray/xi5/xi6/net2_xarray/xi5/xi6/mm0_g) AT=34.900000000n
.measure tran f05c09 FIND v(xdut.n_xarray/xi5/xi10/net2_xarray/xi5/xi10/mm0_g) AT=34.900000000n
.measure tran f05c10 FIND v(xdut.n_xarray/xi5/xi14/net2_xarray/xi5/xi14/mm0_g) AT=34.900000000n
.measure tran f05c11 FIND v(xdut.n_xarray/xi5/xi18/net2_xarray/xi5/xi18/mm0_g) AT=34.900000000n
.measure tran f05c12 FIND v(xdut.n_xarray/xi5/xi22/net2_xarray/xi5/xi22/mm0_g) AT=34.900000000n
.measure tran f05c13 FIND v(xdut.n_xarray/xi5/xi26/net2_xarray/xi5/xi26/mm0_g) AT=34.900000000n
.measure tran f05c14 FIND v(xdut.n_xarray/xi5/xi30/net2_xarray/xi5/xi30/mm0_g) AT=34.900000000n
.measure tran f05c15 FIND v(xdut.n_xarray/xi5/xi34/net2_xarray/xi5/xi34/mm0_g) AT=34.900000000n
.measure tran f05c16 FIND v(xdut.n_xarray/xi5/xi7/net2_xarray/xi5/xi7/mm0_g) AT=34.900000000n
.measure tran f05c17 FIND v(xdut.n_xarray/xi5/xi11/net2_xarray/xi5/xi11/mm0_g) AT=34.900000000n
.measure tran f05c18 FIND v(xdut.n_xarray/xi5/xi15/net2_xarray/xi5/xi15/mm0_g) AT=34.900000000n
.measure tran f05c19 FIND v(xdut.n_xarray/xi5/xi19/net2_xarray/xi5/xi19/mm0_g) AT=34.900000000n
.measure tran f05c20 FIND v(xdut.n_xarray/xi5/xi23/net2_xarray/xi5/xi23/mm0_g) AT=34.900000000n
.measure tran f05c21 FIND v(xdut.n_xarray/xi5/xi27/net2_xarray/xi5/xi27/mm0_g) AT=34.900000000n
.measure tran f05c22 FIND v(xdut.n_xarray/xi5/xi31/net2_xarray/xi5/xi31/mm0_g) AT=34.900000000n
.measure tran f05c23 FIND v(xdut.n_xarray/xi5/xi35/net2_xarray/xi5/xi35/mm0_g) AT=34.900000000n
.measure tran f05c24 FIND v(xdut.n_xarray/xi5/xi8/net2_xarray/xi5/xi8/mm0_g) AT=34.900000000n
.measure tran f05c25 FIND v(xdut.n_xarray/xi5/xi12/net2_xarray/xi5/xi12/mm0_g) AT=34.900000000n
.measure tran f05c26 FIND v(xdut.n_xarray/xi5/xi16/net2_xarray/xi5/xi16/mm0_g) AT=34.900000000n
.measure tran f05c27 FIND v(xdut.n_xarray/xi5/xi20/net2_xarray/xi5/xi20/mm0_g) AT=34.900000000n
.measure tran f05c28 FIND v(xdut.n_xarray/xi5/xi24/net2_xarray/xi5/xi24/mm0_g) AT=34.900000000n
.measure tran f05c29 FIND v(xdut.n_xarray/xi5/xi28/net2_xarray/xi5/xi28/mm0_g) AT=34.900000000n
.measure tran f05c30 FIND v(xdut.n_xarray/xi5/xi32/net2_xarray/xi5/xi32/mm0_g) AT=34.900000000n
.measure tran f05c31 FIND v(xdut.n_xarray/xi5/xi36/net2_xarray/xi5/xi36/mm0_g) AT=34.900000000n
.measure tran f06c00 FIND v(xdut.n_xarray/xi6/xi5/net2_xarray/xi6/xi5/mm0_g) AT=34.900000000n
.measure tran f06c01 FIND v(xdut.n_xarray/xi6/xi9/net2_xarray/xi6/xi9/mm0_g) AT=34.900000000n
.measure tran f06c02 FIND v(xdut.n_xarray/xi6/xi13/net2_xarray/xi6/xi13/mm0_g) AT=34.900000000n
.measure tran f06c03 FIND v(xdut.n_xarray/xi6/xi17/net2_xarray/xi6/xi17/mm0_g) AT=34.900000000n
.measure tran f06c04 FIND v(xdut.n_xarray/xi6/xi21/net2_xarray/xi6/xi21/mm0_g) AT=34.900000000n
.measure tran f06c05 FIND v(xdut.n_xarray/xi6/xi25/net2_xarray/xi6/xi25/mm0_g) AT=34.900000000n
.measure tran f06c06 FIND v(xdut.n_xarray/xi6/xi29/net2_xarray/xi6/xi29/mm0_g) AT=34.900000000n
.measure tran f06c07 FIND v(xdut.n_xarray/xi6/xi33/net2_xarray/xi6/xi33/mm0_g) AT=34.900000000n
.measure tran f06c08 FIND v(xdut.n_xarray/xi6/xi6/net2_xarray/xi6/xi6/mm0_g) AT=34.900000000n
.measure tran f06c09 FIND v(xdut.n_xarray/xi6/xi10/net2_xarray/xi6/xi10/mm0_g) AT=34.900000000n
.measure tran f06c10 FIND v(xdut.n_xarray/xi6/xi14/net2_xarray/xi6/xi14/mm0_g) AT=34.900000000n
.measure tran f06c11 FIND v(xdut.n_xarray/xi6/xi18/net2_xarray/xi6/xi18/mm0_g) AT=34.900000000n
.measure tran f06c12 FIND v(xdut.n_xarray/xi6/xi22/net2_xarray/xi6/xi22/mm0_g) AT=34.900000000n
.measure tran f06c13 FIND v(xdut.n_xarray/xi6/xi26/net2_xarray/xi6/xi26/mm0_g) AT=34.900000000n
.measure tran f06c14 FIND v(xdut.n_xarray/xi6/xi30/net2_xarray/xi6/xi30/mm0_g) AT=34.900000000n
.measure tran f06c15 FIND v(xdut.n_xarray/xi6/xi34/net2_xarray/xi6/xi34/mm0_g) AT=34.900000000n
.measure tran f06c16 FIND v(xdut.n_xarray/xi6/xi7/net2_xarray/xi6/xi7/mm0_g) AT=34.900000000n
.measure tran f06c17 FIND v(xdut.n_xarray/xi6/xi11/net2_xarray/xi6/xi11/mm0_g) AT=34.900000000n
.measure tran f06c18 FIND v(xdut.n_xarray/xi6/xi15/net2_xarray/xi6/xi15/mm0_g) AT=34.900000000n
.measure tran f06c19 FIND v(xdut.n_xarray/xi6/xi19/net2_xarray/xi6/xi19/mm0_g) AT=34.900000000n
.measure tran f06c20 FIND v(xdut.n_xarray/xi6/xi23/net2_xarray/xi6/xi23/mm0_g) AT=34.900000000n
.measure tran f06c21 FIND v(xdut.n_xarray/xi6/xi27/net2_xarray/xi6/xi27/mm0_g) AT=34.900000000n
.measure tran f06c22 FIND v(xdut.n_xarray/xi6/xi31/net2_xarray/xi6/xi31/mm0_g) AT=34.900000000n
.measure tran f06c23 FIND v(xdut.n_xarray/xi6/xi35/net2_xarray/xi6/xi35/mm0_g) AT=34.900000000n
.measure tran f06c24 FIND v(xdut.n_xarray/xi6/xi8/net2_xarray/xi6/xi8/mm0_g) AT=34.900000000n
.measure tran f06c25 FIND v(xdut.n_xarray/xi6/xi12/net2_xarray/xi6/xi12/mm0_g) AT=34.900000000n
.measure tran f06c26 FIND v(xdut.n_xarray/xi6/xi16/net2_xarray/xi6/xi16/mm0_g) AT=34.900000000n
.measure tran f06c27 FIND v(xdut.n_xarray/xi6/xi20/net2_xarray/xi6/xi20/mm0_g) AT=34.900000000n
.measure tran f06c28 FIND v(xdut.n_xarray/xi6/xi24/net2_xarray/xi6/xi24/mm0_g) AT=34.900000000n
.measure tran f06c29 FIND v(xdut.n_xarray/xi6/xi28/net2_xarray/xi6/xi28/mm0_g) AT=34.900000000n
.measure tran f06c30 FIND v(xdut.n_xarray/xi6/xi32/net2_xarray/xi6/xi32/mm0_g) AT=34.900000000n
.measure tran f06c31 FIND v(xdut.n_xarray/xi6/xi36/net2_xarray/xi6/xi36/mm0_g) AT=34.900000000n
.measure tran f07c00 FIND v(xdut.n_xarray/xi7/xi5/net2_xarray/xi7/xi5/mm0_g) AT=34.900000000n
.measure tran f07c01 FIND v(xdut.n_xarray/xi7/xi9/net2_xarray/xi7/xi9/mm0_g) AT=34.900000000n
.measure tran f07c02 FIND v(xdut.n_xarray/xi7/xi13/net2_xarray/xi7/xi13/mm0_g) AT=34.900000000n
.measure tran f07c03 FIND v(xdut.n_xarray/xi7/xi17/net2_xarray/xi7/xi17/mm0_g) AT=34.900000000n
.measure tran f07c04 FIND v(xdut.n_xarray/xi7/xi21/net2_xarray/xi7/xi21/mm0_g) AT=34.900000000n
.measure tran f07c05 FIND v(xdut.n_xarray/xi7/xi25/net2_xarray/xi7/xi25/mm0_g) AT=34.900000000n
.measure tran f07c06 FIND v(xdut.n_xarray/xi7/xi29/net2_xarray/xi7/xi29/mm0_g) AT=34.900000000n
.measure tran f07c07 FIND v(xdut.n_xarray/xi7/xi33/net2_xarray/xi7/xi33/mm0_g) AT=34.900000000n
.measure tran f07c08 FIND v(xdut.n_xarray/xi7/xi6/net2_xarray/xi7/xi6/mm0_g) AT=34.900000000n
.measure tran f07c09 FIND v(xdut.n_xarray/xi7/xi10/net2_xarray/xi7/xi10/mm0_g) AT=34.900000000n
.measure tran f07c10 FIND v(xdut.n_xarray/xi7/xi14/net2_xarray/xi7/xi14/mm0_g) AT=34.900000000n
.measure tran f07c11 FIND v(xdut.n_xarray/xi7/xi18/net2_xarray/xi7/xi18/mm0_g) AT=34.900000000n
.measure tran f07c12 FIND v(xdut.n_xarray/xi7/xi22/net2_xarray/xi7/xi22/mm0_g) AT=34.900000000n
.measure tran f07c13 FIND v(xdut.n_xarray/xi7/xi26/net2_xarray/xi7/xi26/mm0_g) AT=34.900000000n
.measure tran f07c14 FIND v(xdut.n_xarray/xi7/xi30/net2_xarray/xi7/xi30/mm0_g) AT=34.900000000n
.measure tran f07c15 FIND v(xdut.n_xarray/xi7/xi34/net2_xarray/xi7/xi34/mm0_g) AT=34.900000000n
.measure tran f07c16 FIND v(xdut.n_xarray/xi7/xi7/net2_xarray/xi7/xi7/mm0_g) AT=34.900000000n
.measure tran f07c17 FIND v(xdut.n_xarray/xi7/xi11/net2_xarray/xi7/xi11/mm0_g) AT=34.900000000n
.measure tran f07c18 FIND v(xdut.n_xarray/xi7/xi15/net2_xarray/xi7/xi15/mm0_g) AT=34.900000000n
.measure tran f07c19 FIND v(xdut.n_xarray/xi7/xi19/net2_xarray/xi7/xi19/mm0_g) AT=34.900000000n
.measure tran f07c20 FIND v(xdut.n_xarray/xi7/xi23/net2_xarray/xi7/xi23/mm0_g) AT=34.900000000n
.measure tran f07c21 FIND v(xdut.n_xarray/xi7/xi27/net2_xarray/xi7/xi27/mm0_g) AT=34.900000000n
.measure tran f07c22 FIND v(xdut.n_xarray/xi7/xi31/net2_xarray/xi7/xi31/mm0_g) AT=34.900000000n
.measure tran f07c23 FIND v(xdut.n_xarray/xi7/xi35/net2_xarray/xi7/xi35/mm0_g) AT=34.900000000n
.measure tran f07c24 FIND v(xdut.n_xarray/xi7/xi8/net2_xarray/xi7/xi8/mm0_g) AT=34.900000000n
.measure tran f07c25 FIND v(xdut.n_xarray/xi7/xi12/net2_xarray/xi7/xi12/mm0_g) AT=34.900000000n
.measure tran f07c26 FIND v(xdut.n_xarray/xi7/xi16/net2_xarray/xi7/xi16/mm0_g) AT=34.900000000n
.measure tran f07c27 FIND v(xdut.n_xarray/xi7/xi20/net2_xarray/xi7/xi20/mm0_g) AT=34.900000000n
.measure tran f07c28 FIND v(xdut.n_xarray/xi7/xi24/net2_xarray/xi7/xi24/mm0_g) AT=34.900000000n
.measure tran f07c29 FIND v(xdut.n_xarray/xi7/xi28/net2_xarray/xi7/xi28/mm0_g) AT=34.900000000n
.measure tran f07c30 FIND v(xdut.n_xarray/xi7/xi32/net2_xarray/xi7/xi32/mm0_g) AT=34.900000000n
.measure tran f07c31 FIND v(xdut.n_xarray/xi7/xi36/net2_xarray/xi7/xi36/mm0_g) AT=34.900000000n
.measure tran f08c00 FIND v(xdut.n_xarray/xi8/xi5/net2_xarray/xi8/xi5/mm0_g) AT=34.900000000n
.measure tran f08c01 FIND v(xdut.n_xarray/xi8/xi9/net2_xarray/xi8/xi9/mm0_g) AT=34.900000000n
.measure tran f08c02 FIND v(xdut.n_xarray/xi8/xi13/net2_xarray/xi8/xi13/mm0_g) AT=34.900000000n
.measure tran f08c03 FIND v(xdut.n_xarray/xi8/xi17/net2_xarray/xi8/xi17/mm0_g) AT=34.900000000n
.measure tran f08c04 FIND v(xdut.n_xarray/xi8/xi21/net2_xarray/xi8/xi21/mm0_g) AT=34.900000000n
.measure tran f08c05 FIND v(xdut.n_xarray/xi8/xi25/net2_xarray/xi8/xi25/mm0_g) AT=34.900000000n
.measure tran f08c06 FIND v(xdut.n_xarray/xi8/xi29/net2_xarray/xi8/xi29/mm0_g) AT=34.900000000n
.measure tran f08c07 FIND v(xdut.n_xarray/xi8/xi33/net2_xarray/xi8/xi33/mm0_g) AT=34.900000000n
.measure tran f08c08 FIND v(xdut.n_xarray/xi8/xi6/net2_xarray/xi8/xi6/mm0_g) AT=34.900000000n
.measure tran f08c09 FIND v(xdut.n_xarray/xi8/xi10/net2_xarray/xi8/xi10/mm0_g) AT=34.900000000n
.measure tran f08c10 FIND v(xdut.n_xarray/xi8/xi14/net2_xarray/xi8/xi14/mm0_g) AT=34.900000000n
.measure tran f08c11 FIND v(xdut.n_xarray/xi8/xi18/net2_xarray/xi8/xi18/mm0_g) AT=34.900000000n
.measure tran f08c12 FIND v(xdut.n_xarray/xi8/xi22/net2_xarray/xi8/xi22/mm0_g) AT=34.900000000n
.measure tran f08c13 FIND v(xdut.n_xarray/xi8/xi26/net2_xarray/xi8/xi26/mm0_g) AT=34.900000000n
.measure tran f08c14 FIND v(xdut.n_xarray/xi8/xi30/net2_xarray/xi8/xi30/mm0_g) AT=34.900000000n
.measure tran f08c15 FIND v(xdut.n_xarray/xi8/xi34/net2_xarray/xi8/xi34/mm0_g) AT=34.900000000n
.measure tran f08c16 FIND v(xdut.n_xarray/xi8/xi7/net2_xarray/xi8/xi7/mm0_g) AT=34.900000000n
.measure tran f08c17 FIND v(xdut.n_xarray/xi8/xi11/net2_xarray/xi8/xi11/mm0_g) AT=34.900000000n
.measure tran f08c18 FIND v(xdut.n_xarray/xi8/xi15/net2_xarray/xi8/xi15/mm0_g) AT=34.900000000n
.measure tran f08c19 FIND v(xdut.n_xarray/xi8/xi19/net2_xarray/xi8/xi19/mm0_g) AT=34.900000000n
.measure tran f08c20 FIND v(xdut.n_xarray/xi8/xi23/net2_xarray/xi8/xi23/mm0_g) AT=34.900000000n
.measure tran f08c21 FIND v(xdut.n_xarray/xi8/xi27/net2_xarray/xi8/xi27/mm0_g) AT=34.900000000n
.measure tran f08c22 FIND v(xdut.n_xarray/xi8/xi31/net2_xarray/xi8/xi31/mm0_g) AT=34.900000000n
.measure tran f08c23 FIND v(xdut.n_xarray/xi8/xi35/net2_xarray/xi8/xi35/mm0_g) AT=34.900000000n
.measure tran f08c24 FIND v(xdut.n_xarray/xi8/xi8/net2_xarray/xi8/xi8/mm0_g) AT=34.900000000n
.measure tran f08c25 FIND v(xdut.n_xarray/xi8/xi12/net2_xarray/xi8/xi12/mm0_g) AT=34.900000000n
.measure tran f08c26 FIND v(xdut.n_xarray/xi8/xi16/net2_xarray/xi8/xi16/mm0_g) AT=34.900000000n
.measure tran f08c27 FIND v(xdut.n_xarray/xi8/xi20/net2_xarray/xi8/xi20/mm0_g) AT=34.900000000n
.measure tran f08c28 FIND v(xdut.n_xarray/xi8/xi24/net2_xarray/xi8/xi24/mm0_g) AT=34.900000000n
.measure tran f08c29 FIND v(xdut.n_xarray/xi8/xi28/net2_xarray/xi8/xi28/mm0_g) AT=34.900000000n
.measure tran f08c30 FIND v(xdut.n_xarray/xi8/xi32/net2_xarray/xi8/xi32/mm0_g) AT=34.900000000n
.measure tran f08c31 FIND v(xdut.n_xarray/xi8/xi36/net2_xarray/xi8/xi36/mm0_g) AT=34.900000000n
.measure tran f09c00 FIND v(xdut.n_xarray/xi9/xi5/net2_xarray/xi9/xi5/mm0_g) AT=34.900000000n
.measure tran f09c01 FIND v(xdut.n_xarray/xi9/xi9/net2_xarray/xi9/xi9/mm0_g) AT=34.900000000n
.measure tran f09c02 FIND v(xdut.n_xarray/xi9/xi13/net2_xarray/xi9/xi13/mm0_g) AT=34.900000000n
.measure tran f09c03 FIND v(xdut.n_xarray/xi9/xi17/net2_xarray/xi9/xi17/mm0_g) AT=34.900000000n
.measure tran f09c04 FIND v(xdut.n_xarray/xi9/xi21/net2_xarray/xi9/xi21/mm0_g) AT=34.900000000n
.measure tran f09c05 FIND v(xdut.n_xarray/xi9/xi25/net2_xarray/xi9/xi25/mm0_g) AT=34.900000000n
.measure tran f09c06 FIND v(xdut.n_xarray/xi9/xi29/net2_xarray/xi9/xi29/mm0_g) AT=34.900000000n
.measure tran f09c07 FIND v(xdut.n_xarray/xi9/xi33/net2_xarray/xi9/xi33/mm0_g) AT=34.900000000n
.measure tran f09c08 FIND v(xdut.n_xarray/xi9/xi6/net2_xarray/xi9/xi6/mm0_g) AT=34.900000000n
.measure tran f09c09 FIND v(xdut.n_xarray/xi9/xi10/net2_xarray/xi9/xi10/mm0_g) AT=34.900000000n
.measure tran f09c10 FIND v(xdut.n_xarray/xi9/xi14/net2_xarray/xi9/xi14/mm0_g) AT=34.900000000n
.measure tran f09c11 FIND v(xdut.n_xarray/xi9/xi18/net2_xarray/xi9/xi18/mm0_g) AT=34.900000000n
.measure tran f09c12 FIND v(xdut.n_xarray/xi9/xi22/net2_xarray/xi9/xi22/mm0_g) AT=34.900000000n
.measure tran f09c13 FIND v(xdut.n_xarray/xi9/xi26/net2_xarray/xi9/xi26/mm0_g) AT=34.900000000n
.measure tran f09c14 FIND v(xdut.n_xarray/xi9/xi30/net2_xarray/xi9/xi30/mm0_g) AT=34.900000000n
.measure tran f09c15 FIND v(xdut.n_xarray/xi9/xi34/net2_xarray/xi9/xi34/mm0_g) AT=34.900000000n
.measure tran f09c16 FIND v(xdut.n_xarray/xi9/xi7/net2_xarray/xi9/xi7/mm0_g) AT=34.900000000n
.measure tran f09c17 FIND v(xdut.n_xarray/xi9/xi11/net2_xarray/xi9/xi11/mm0_g) AT=34.900000000n
.measure tran f09c18 FIND v(xdut.n_xarray/xi9/xi15/net2_xarray/xi9/xi15/mm0_g) AT=34.900000000n
.measure tran f09c19 FIND v(xdut.n_xarray/xi9/xi19/net2_xarray/xi9/xi19/mm0_g) AT=34.900000000n
.measure tran f09c20 FIND v(xdut.n_xarray/xi9/xi23/net2_xarray/xi9/xi23/mm0_g) AT=34.900000000n
.measure tran f09c21 FIND v(xdut.n_xarray/xi9/xi27/net2_xarray/xi9/xi27/mm0_g) AT=34.900000000n
.measure tran f09c22 FIND v(xdut.n_xarray/xi9/xi31/net2_xarray/xi9/xi31/mm0_g) AT=34.900000000n
.measure tran f09c23 FIND v(xdut.n_xarray/xi9/xi35/net2_xarray/xi9/xi35/mm0_g) AT=34.900000000n
.measure tran f09c24 FIND v(xdut.n_xarray/xi9/xi8/net2_xarray/xi9/xi8/mm0_g) AT=34.900000000n
.measure tran f09c25 FIND v(xdut.n_xarray/xi9/xi12/net2_xarray/xi9/xi12/mm0_g) AT=34.900000000n
.measure tran f09c26 FIND v(xdut.n_xarray/xi9/xi16/net2_xarray/xi9/xi16/mm0_g) AT=34.900000000n
.measure tran f09c27 FIND v(xdut.n_xarray/xi9/xi20/net2_xarray/xi9/xi20/mm0_g) AT=34.900000000n
.measure tran f09c28 FIND v(xdut.n_xarray/xi9/xi24/net2_xarray/xi9/xi24/mm0_g) AT=34.900000000n
.measure tran f09c29 FIND v(xdut.n_xarray/xi9/xi28/net2_xarray/xi9/xi28/mm0_g) AT=34.900000000n
.measure tran f09c30 FIND v(xdut.n_xarray/xi9/xi32/net2_xarray/xi9/xi32/mm0_g) AT=34.900000000n
.measure tran f09c31 FIND v(xdut.n_xarray/xi9/xi36/net2_xarray/xi9/xi36/mm0_g) AT=34.900000000n
.measure tran f10c00 FIND v(xdut.n_xarray/xi10/xi5/net2_xarray/xi10/xi5/mm0_g) AT=34.900000000n
.measure tran f10c01 FIND v(xdut.n_xarray/xi10/xi9/net2_xarray/xi10/xi9/mm0_g) AT=34.900000000n
.measure tran f10c02 FIND v(xdut.n_xarray/xi10/xi13/net2_xarray/xi10/xi13/mm0_g) AT=34.900000000n
.measure tran f10c03 FIND v(xdut.n_xarray/xi10/xi17/net2_xarray/xi10/xi17/mm0_g) AT=34.900000000n
.measure tran f10c04 FIND v(xdut.n_xarray/xi10/xi21/net2_xarray/xi10/xi21/mm0_g) AT=34.900000000n
.measure tran f10c05 FIND v(xdut.n_xarray/xi10/xi25/net2_xarray/xi10/xi25/mm0_g) AT=34.900000000n
.measure tran f10c06 FIND v(xdut.n_xarray/xi10/xi29/net2_xarray/xi10/xi29/mm0_g) AT=34.900000000n
.measure tran f10c07 FIND v(xdut.n_xarray/xi10/xi33/net2_xarray/xi10/xi33/mm0_g) AT=34.900000000n
.measure tran f10c08 FIND v(xdut.n_xarray/xi10/xi6/net2_xarray/xi10/xi6/mm0_g) AT=34.900000000n
.measure tran f10c09 FIND v(xdut.n_xarray/xi10/xi10/net2_xarray/xi10/xi10/mm0_g) AT=34.900000000n
.measure tran f10c10 FIND v(xdut.n_xarray/xi10/xi14/net2_xarray/xi10/xi14/mm0_g) AT=34.900000000n
.measure tran f10c11 FIND v(xdut.n_xarray/xi10/xi18/net2_xarray/xi10/xi18/mm0_g) AT=34.900000000n
.measure tran f10c12 FIND v(xdut.n_xarray/xi10/xi22/net2_xarray/xi10/xi22/mm0_g) AT=34.900000000n
.measure tran f10c13 FIND v(xdut.n_xarray/xi10/xi26/net2_xarray/xi10/xi26/mm0_g) AT=34.900000000n
.measure tran f10c14 FIND v(xdut.n_xarray/xi10/xi30/net2_xarray/xi10/xi30/mm0_g) AT=34.900000000n
.measure tran f10c15 FIND v(xdut.n_xarray/xi10/xi34/net2_xarray/xi10/xi34/mm0_g) AT=34.900000000n
.measure tran f10c16 FIND v(xdut.n_xarray/xi10/xi7/net2_xarray/xi10/xi7/mm0_g) AT=34.900000000n
.measure tran f10c17 FIND v(xdut.n_xarray/xi10/xi11/net2_xarray/xi10/xi11/mm0_g) AT=34.900000000n
.measure tran f10c18 FIND v(xdut.n_xarray/xi10/xi15/net2_xarray/xi10/xi15/mm0_g) AT=34.900000000n
.measure tran f10c19 FIND v(xdut.n_xarray/xi10/xi19/net2_xarray/xi10/xi19/mm0_g) AT=34.900000000n
.measure tran f10c20 FIND v(xdut.n_xarray/xi10/xi23/net2_xarray/xi10/xi23/mm0_g) AT=34.900000000n
.measure tran f10c21 FIND v(xdut.n_xarray/xi10/xi27/net2_xarray/xi10/xi27/mm0_g) AT=34.900000000n
.measure tran f10c22 FIND v(xdut.n_xarray/xi10/xi31/net2_xarray/xi10/xi31/mm0_g) AT=34.900000000n
.measure tran f10c23 FIND v(xdut.n_xarray/xi10/xi35/net2_xarray/xi10/xi35/mm0_g) AT=34.900000000n
.measure tran f10c24 FIND v(xdut.n_xarray/xi10/xi8/net2_xarray/xi10/xi8/mm0_g) AT=34.900000000n
.measure tran f10c25 FIND v(xdut.n_xarray/xi10/xi12/net2_xarray/xi10/xi12/mm0_g) AT=34.900000000n
.measure tran f10c26 FIND v(xdut.n_xarray/xi10/xi16/net2_xarray/xi10/xi16/mm0_g) AT=34.900000000n
.measure tran f10c27 FIND v(xdut.n_xarray/xi10/xi20/net2_xarray/xi10/xi20/mm0_g) AT=34.900000000n
.measure tran f10c28 FIND v(xdut.n_xarray/xi10/xi24/net2_xarray/xi10/xi24/mm0_g) AT=34.900000000n
.measure tran f10c29 FIND v(xdut.n_xarray/xi10/xi28/net2_xarray/xi10/xi28/mm0_g) AT=34.900000000n
.measure tran f10c30 FIND v(xdut.n_xarray/xi10/xi32/net2_xarray/xi10/xi32/mm0_g) AT=34.900000000n
.measure tran f10c31 FIND v(xdut.n_xarray/xi10/xi36/net2_xarray/xi10/xi36/mm0_g) AT=34.900000000n
.measure tran f11c00 FIND v(xdut.n_xarray/xi11/xi5/net2_xarray/xi11/xi5/mm0_g) AT=34.900000000n
.measure tran f11c01 FIND v(xdut.n_xarray/xi11/xi9/net2_xarray/xi11/xi9/mm0_g) AT=34.900000000n
.measure tran f11c02 FIND v(xdut.n_xarray/xi11/xi13/net2_xarray/xi11/xi13/mm0_g) AT=34.900000000n
.measure tran f11c03 FIND v(xdut.n_xarray/xi11/xi17/net2_xarray/xi11/xi17/mm0_g) AT=34.900000000n
.measure tran f11c04 FIND v(xdut.n_xarray/xi11/xi21/net2_xarray/xi11/xi21/mm0_g) AT=34.900000000n
.measure tran f11c05 FIND v(xdut.n_xarray/xi11/xi25/net2_xarray/xi11/xi25/mm0_g) AT=34.900000000n
.measure tran f11c06 FIND v(xdut.n_xarray/xi11/xi29/net2_xarray/xi11/xi29/mm0_g) AT=34.900000000n
.measure tran f11c07 FIND v(xdut.n_xarray/xi11/xi33/net2_xarray/xi11/xi33/mm0_g) AT=34.900000000n
.measure tran f11c08 FIND v(xdut.n_xarray/xi11/xi6/net2_xarray/xi11/xi6/mm0_g) AT=34.900000000n
.measure tran f11c09 FIND v(xdut.n_xarray/xi11/xi10/net2_xarray/xi11/xi10/mm0_g) AT=34.900000000n
.measure tran f11c10 FIND v(xdut.n_xarray/xi11/xi14/net2_xarray/xi11/xi14/mm0_g) AT=34.900000000n
.measure tran f11c11 FIND v(xdut.n_xarray/xi11/xi18/net2_xarray/xi11/xi18/mm0_g) AT=34.900000000n
.measure tran f11c12 FIND v(xdut.n_xarray/xi11/xi22/net2_xarray/xi11/xi22/mm0_g) AT=34.900000000n
.measure tran f11c13 FIND v(xdut.n_xarray/xi11/xi26/net2_xarray/xi11/xi26/mm0_g) AT=34.900000000n
.measure tran f11c14 FIND v(xdut.n_xarray/xi11/xi30/net2_xarray/xi11/xi30/mm0_g) AT=34.900000000n
.measure tran f11c15 FIND v(xdut.n_xarray/xi11/xi34/net2_xarray/xi11/xi34/mm0_g) AT=34.900000000n
.measure tran f11c16 FIND v(xdut.n_xarray/xi11/xi7/net2_xarray/xi11/xi7/mm0_g) AT=34.900000000n
.measure tran f11c17 FIND v(xdut.n_xarray/xi11/xi11/net2_xarray/xi11/xi11/mm0_g) AT=34.900000000n
.measure tran f11c18 FIND v(xdut.n_xarray/xi11/xi15/net2_xarray/xi11/xi15/mm0_g) AT=34.900000000n
.measure tran f11c19 FIND v(xdut.n_xarray/xi11/xi19/net2_xarray/xi11/xi19/mm0_g) AT=34.900000000n
.measure tran f11c20 FIND v(xdut.n_xarray/xi11/xi23/net2_xarray/xi11/xi23/mm0_g) AT=34.900000000n
.measure tran f11c21 FIND v(xdut.n_xarray/xi11/xi27/net2_xarray/xi11/xi27/mm0_g) AT=34.900000000n
.measure tran f11c22 FIND v(xdut.n_xarray/xi11/xi31/net2_xarray/xi11/xi31/mm0_g) AT=34.900000000n
.measure tran f11c23 FIND v(xdut.n_xarray/xi11/xi35/net2_xarray/xi11/xi35/mm0_g) AT=34.900000000n
.measure tran f11c24 FIND v(xdut.n_xarray/xi11/xi8/net2_xarray/xi11/xi8/mm0_g) AT=34.900000000n
.measure tran f11c25 FIND v(xdut.n_xarray/xi11/xi12/net2_xarray/xi11/xi12/mm0_g) AT=34.900000000n
.measure tran f11c26 FIND v(xdut.n_xarray/xi11/xi16/net2_xarray/xi11/xi16/mm0_g) AT=34.900000000n
.measure tran f11c27 FIND v(xdut.n_xarray/xi11/xi20/net2_xarray/xi11/xi20/mm0_g) AT=34.900000000n
.measure tran f11c28 FIND v(xdut.n_xarray/xi11/xi24/net2_xarray/xi11/xi24/mm0_g) AT=34.900000000n
.measure tran f11c29 FIND v(xdut.n_xarray/xi11/xi28/net2_xarray/xi11/xi28/mm0_g) AT=34.900000000n
.measure tran f11c30 FIND v(xdut.n_xarray/xi11/xi32/net2_xarray/xi11/xi32/mm0_g) AT=34.900000000n
.measure tran f11c31 FIND v(xdut.n_xarray/xi11/xi36/net2_xarray/xi11/xi36/mm0_g) AT=34.900000000n
.measure tran f12c00 FIND v(xdut.n_xarray/xi12/xi5/net2_xarray/xi12/xi5/mm0_g) AT=34.900000000n
.measure tran f12c01 FIND v(xdut.n_xarray/xi12/xi9/net2_xarray/xi12/xi9/mm0_g) AT=34.900000000n
.measure tran f12c02 FIND v(xdut.n_xarray/xi12/xi13/net2_xarray/xi12/xi13/mm0_g) AT=34.900000000n
.measure tran f12c03 FIND v(xdut.n_xarray/xi12/xi17/net2_xarray/xi12/xi17/mm0_g) AT=34.900000000n
.measure tran f12c04 FIND v(xdut.n_xarray/xi12/xi21/net2_xarray/xi12/xi21/mm0_g) AT=34.900000000n
.measure tran f12c05 FIND v(xdut.n_xarray/xi12/xi25/net2_xarray/xi12/xi25/mm0_g) AT=34.900000000n
.measure tran f12c06 FIND v(xdut.n_xarray/xi12/xi29/net2_xarray/xi12/xi29/mm0_g) AT=34.900000000n
.measure tran f12c07 FIND v(xdut.n_xarray/xi12/xi33/net2_xarray/xi12/xi33/mm0_g) AT=34.900000000n
.measure tran f12c08 FIND v(xdut.n_xarray/xi12/xi6/net2_xarray/xi12/xi6/mm0_g) AT=34.900000000n
.measure tran f12c09 FIND v(xdut.n_xarray/xi12/xi10/net2_xarray/xi12/xi10/mm0_g) AT=34.900000000n
.measure tran f12c10 FIND v(xdut.n_xarray/xi12/xi14/net2_xarray/xi12/xi14/mm0_g) AT=34.900000000n
.measure tran f12c11 FIND v(xdut.n_xarray/xi12/xi18/net2_xarray/xi12/xi18/mm0_g) AT=34.900000000n
.measure tran f12c12 FIND v(xdut.n_xarray/xi12/xi22/net2_xarray/xi12/xi22/mm0_g) AT=34.900000000n
.measure tran f12c13 FIND v(xdut.n_xarray/xi12/xi26/net2_xarray/xi12/xi26/mm0_g) AT=34.900000000n
.measure tran f12c14 FIND v(xdut.n_xarray/xi12/xi30/net2_xarray/xi12/xi30/mm0_g) AT=34.900000000n
.measure tran f12c15 FIND v(xdut.n_xarray/xi12/xi34/net2_xarray/xi12/xi34/mm0_g) AT=34.900000000n
.measure tran f12c16 FIND v(xdut.n_xarray/xi12/xi7/net2_xarray/xi12/xi7/mm0_g) AT=34.900000000n
.measure tran f12c17 FIND v(xdut.n_xarray/xi12/xi11/net2_xarray/xi12/xi11/mm0_g) AT=34.900000000n
.measure tran f12c18 FIND v(xdut.n_xarray/xi12/xi15/net2_xarray/xi12/xi15/mm0_g) AT=34.900000000n
.measure tran f12c19 FIND v(xdut.n_xarray/xi12/xi19/net2_xarray/xi12/xi19/mm0_g) AT=34.900000000n
.measure tran f12c20 FIND v(xdut.n_xarray/xi12/xi23/net2_xarray/xi12/xi23/mm0_g) AT=34.900000000n
.measure tran f12c21 FIND v(xdut.n_xarray/xi12/xi27/net2_xarray/xi12/xi27/mm0_g) AT=34.900000000n
.measure tran f12c22 FIND v(xdut.n_xarray/xi12/xi31/net2_xarray/xi12/xi31/mm0_g) AT=34.900000000n
.measure tran f12c23 FIND v(xdut.n_xarray/xi12/xi35/net2_xarray/xi12/xi35/mm0_g) AT=34.900000000n
.measure tran f12c24 FIND v(xdut.n_xarray/xi12/xi8/net2_xarray/xi12/xi8/mm0_g) AT=34.900000000n
.measure tran f12c25 FIND v(xdut.n_xarray/xi12/xi12/net2_xarray/xi12/xi12/mm0_g) AT=34.900000000n
.measure tran f12c26 FIND v(xdut.n_xarray/xi12/xi16/net2_xarray/xi12/xi16/mm0_g) AT=34.900000000n
.measure tran f12c27 FIND v(xdut.n_xarray/xi12/xi20/net2_xarray/xi12/xi20/mm0_g) AT=34.900000000n
.measure tran f12c28 FIND v(xdut.n_xarray/xi12/xi24/net2_xarray/xi12/xi24/mm0_g) AT=34.900000000n
.measure tran f12c29 FIND v(xdut.n_xarray/xi12/xi28/net2_xarray/xi12/xi28/mm0_g) AT=34.900000000n
.measure tran f12c30 FIND v(xdut.n_xarray/xi12/xi32/net2_xarray/xi12/xi32/mm0_g) AT=34.900000000n
.measure tran f12c31 FIND v(xdut.n_xarray/xi12/xi36/net2_xarray/xi12/xi36/mm0_g) AT=34.900000000n
.measure tran f13c00 FIND v(xdut.n_xarray/xi13/xi5/net2_xarray/xi13/xi5/mm0_g) AT=34.900000000n
.measure tran f13c01 FIND v(xdut.n_xarray/xi13/xi9/net2_xarray/xi13/xi9/mm0_g) AT=34.900000000n
.measure tran f13c02 FIND v(xdut.n_xarray/xi13/xi13/net2_xarray/xi13/xi13/mm0_g) AT=34.900000000n
.measure tran f13c03 FIND v(xdut.n_xarray/xi13/xi17/net2_xarray/xi13/xi17/mm0_g) AT=34.900000000n
.measure tran f13c04 FIND v(xdut.n_xarray/xi13/xi21/net2_xarray/xi13/xi21/mm0_g) AT=34.900000000n
.measure tran f13c05 FIND v(xdut.n_xarray/xi13/xi25/net2_xarray/xi13/xi25/mm0_g) AT=34.900000000n
.measure tran f13c06 FIND v(xdut.n_xarray/xi13/xi29/net2_xarray/xi13/xi29/mm0_g) AT=34.900000000n
.measure tran f13c07 FIND v(xdut.n_xarray/xi13/xi33/net2_xarray/xi13/xi33/mm0_g) AT=34.900000000n
.measure tran f13c08 FIND v(xdut.n_xarray/xi13/xi6/net2_xarray/xi13/xi6/mm0_g) AT=34.900000000n
.measure tran f13c09 FIND v(xdut.n_xarray/xi13/xi10/net2_xarray/xi13/xi10/mm0_g) AT=34.900000000n
.measure tran f13c10 FIND v(xdut.n_xarray/xi13/xi14/net2_xarray/xi13/xi14/mm0_g) AT=34.900000000n
.measure tran f13c11 FIND v(xdut.n_xarray/xi13/xi18/net2_xarray/xi13/xi18/mm0_g) AT=34.900000000n
.measure tran f13c12 FIND v(xdut.n_xarray/xi13/xi22/net2_xarray/xi13/xi22/mm0_g) AT=34.900000000n
.measure tran f13c13 FIND v(xdut.n_xarray/xi13/xi26/net2_xarray/xi13/xi26/mm0_g) AT=34.900000000n
.measure tran f13c14 FIND v(xdut.n_xarray/xi13/xi30/net2_xarray/xi13/xi30/mm0_g) AT=34.900000000n
.measure tran f13c15 FIND v(xdut.n_xarray/xi13/xi34/net2_xarray/xi13/xi34/mm0_g) AT=34.900000000n
.measure tran f13c16 FIND v(xdut.n_xarray/xi13/xi7/net2_xarray/xi13/xi7/mm0_g) AT=34.900000000n
.measure tran f13c17 FIND v(xdut.n_xarray/xi13/xi11/net2_xarray/xi13/xi11/mm0_g) AT=34.900000000n
.measure tran f13c18 FIND v(xdut.n_xarray/xi13/xi15/net2_xarray/xi13/xi15/mm0_g) AT=34.900000000n
.measure tran f13c19 FIND v(xdut.n_xarray/xi13/xi19/net2_xarray/xi13/xi19/mm0_g) AT=34.900000000n
.measure tran f13c20 FIND v(xdut.n_xarray/xi13/xi23/net2_xarray/xi13/xi23/mm0_g) AT=34.900000000n
.measure tran f13c21 FIND v(xdut.n_xarray/xi13/xi27/net2_xarray/xi13/xi27/mm0_g) AT=34.900000000n
.measure tran f13c22 FIND v(xdut.n_xarray/xi13/xi31/net2_xarray/xi13/xi31/mm0_g) AT=34.900000000n
.measure tran f13c23 FIND v(xdut.n_xarray/xi13/xi35/net2_xarray/xi13/xi35/mm0_g) AT=34.900000000n
.measure tran f13c24 FIND v(xdut.n_xarray/xi13/xi8/net2_xarray/xi13/xi8/mm0_g) AT=34.900000000n
.measure tran f13c25 FIND v(xdut.n_xarray/xi13/xi12/net2_xarray/xi13/xi12/mm0_g) AT=34.900000000n
.measure tran f13c26 FIND v(xdut.n_xarray/xi13/xi16/net2_xarray/xi13/xi16/mm0_g) AT=34.900000000n
.measure tran f13c27 FIND v(xdut.n_xarray/xi13/xi20/net2_xarray/xi13/xi20/mm0_g) AT=34.900000000n
.measure tran f13c28 FIND v(xdut.n_xarray/xi13/xi24/net2_xarray/xi13/xi24/mm0_g) AT=34.900000000n
.measure tran f13c29 FIND v(xdut.n_xarray/xi13/xi28/net2_xarray/xi13/xi28/mm0_g) AT=34.900000000n
.measure tran f13c30 FIND v(xdut.n_xarray/xi13/xi32/net2_xarray/xi13/xi32/mm0_g) AT=34.900000000n
.measure tran f13c31 FIND v(xdut.n_xarray/xi13/xi36/net2_xarray/xi13/xi36/mm0_g) AT=34.900000000n
.measure tran f14c00 FIND v(xdut.n_xarray/xi14/xi5/net2_xarray/xi14/xi5/mm0_g) AT=34.900000000n
.measure tran f14c01 FIND v(xdut.n_xarray/xi14/xi9/net2_xarray/xi14/xi9/mm0_g) AT=34.900000000n
.measure tran f14c02 FIND v(xdut.n_xarray/xi14/xi13/net2_xarray/xi14/xi13/mm0_g) AT=34.900000000n
.measure tran f14c03 FIND v(xdut.n_xarray/xi14/xi17/net2_xarray/xi14/xi17/mm0_g) AT=34.900000000n
.measure tran f14c04 FIND v(xdut.n_xarray/xi14/xi21/net2_xarray/xi14/xi21/mm0_g) AT=34.900000000n
.measure tran f14c05 FIND v(xdut.n_xarray/xi14/xi25/net2_xarray/xi14/xi25/mm0_g) AT=34.900000000n
.measure tran f14c06 FIND v(xdut.n_xarray/xi14/xi29/net2_xarray/xi14/xi29/mm0_g) AT=34.900000000n
.measure tran f14c07 FIND v(xdut.n_xarray/xi14/xi33/net2_xarray/xi14/xi33/mm0_g) AT=34.900000000n
.measure tran f14c08 FIND v(xdut.n_xarray/xi14/xi6/net2_xarray/xi14/xi6/mm0_g) AT=34.900000000n
.measure tran f14c09 FIND v(xdut.n_xarray/xi14/xi10/net2_xarray/xi14/xi10/mm0_g) AT=34.900000000n
.measure tran f14c10 FIND v(xdut.n_xarray/xi14/xi14/net2_xarray/xi14/xi14/mm0_g) AT=34.900000000n
.measure tran f14c11 FIND v(xdut.n_xarray/xi14/xi18/net2_xarray/xi14/xi18/mm0_g) AT=34.900000000n
.measure tran f14c12 FIND v(xdut.n_xarray/xi14/xi22/net2_xarray/xi14/xi22/mm0_g) AT=34.900000000n
.measure tran f14c13 FIND v(xdut.n_xarray/xi14/xi26/net2_xarray/xi14/xi26/mm0_g) AT=34.900000000n
.measure tran f14c14 FIND v(xdut.n_xarray/xi14/xi30/net2_xarray/xi14/xi30/mm0_g) AT=34.900000000n
.measure tran f14c15 FIND v(xdut.n_xarray/xi14/xi34/net2_xarray/xi14/xi34/mm0_g) AT=34.900000000n
.measure tran f14c16 FIND v(xdut.n_xarray/xi14/xi7/net2_xarray/xi14/xi7/mm0_g) AT=34.900000000n
.measure tran f14c17 FIND v(xdut.n_xarray/xi14/xi11/net2_xarray/xi14/xi11/mm0_g) AT=34.900000000n
.measure tran f14c18 FIND v(xdut.n_xarray/xi14/xi15/net2_xarray/xi14/xi15/mm0_g) AT=34.900000000n
.measure tran f14c19 FIND v(xdut.n_xarray/xi14/xi19/net2_xarray/xi14/xi19/mm0_g) AT=34.900000000n
.measure tran f14c20 FIND v(xdut.n_xarray/xi14/xi23/net2_xarray/xi14/xi23/mm0_g) AT=34.900000000n
.measure tran f14c21 FIND v(xdut.n_xarray/xi14/xi27/net2_xarray/xi14/xi27/mm0_g) AT=34.900000000n
.measure tran f14c22 FIND v(xdut.n_xarray/xi14/xi31/net2_xarray/xi14/xi31/mm0_g) AT=34.900000000n
.measure tran f14c23 FIND v(xdut.n_xarray/xi14/xi35/net2_xarray/xi14/xi35/mm0_g) AT=34.900000000n
.measure tran f14c24 FIND v(xdut.n_xarray/xi14/xi8/net2_xarray/xi14/xi8/mm0_g) AT=34.900000000n
.measure tran f14c25 FIND v(xdut.n_xarray/xi14/xi12/net2_xarray/xi14/xi12/mm0_g) AT=34.900000000n
.measure tran f14c26 FIND v(xdut.n_xarray/xi14/xi16/net2_xarray/xi14/xi16/mm0_g) AT=34.900000000n
.measure tran f14c27 FIND v(xdut.n_xarray/xi14/xi20/net2_xarray/xi14/xi20/mm0_g) AT=34.900000000n
.measure tran f14c28 FIND v(xdut.n_xarray/xi14/xi24/net2_xarray/xi14/xi24/mm0_g) AT=34.900000000n
.measure tran f14c29 FIND v(xdut.n_xarray/xi14/xi28/net2_xarray/xi14/xi28/mm0_g) AT=34.900000000n
.measure tran f14c30 FIND v(xdut.n_xarray/xi14/xi32/net2_xarray/xi14/xi32/mm0_g) AT=34.900000000n
.measure tran f14c31 FIND v(xdut.n_xarray/xi14/xi36/net2_xarray/xi14/xi36/mm0_g) AT=34.900000000n
.measure tran f15c00 FIND v(xdut.n_xarray/xi15/xi5/net2_xarray/xi15/xi5/mm0_g) AT=34.900000000n
.measure tran f15c01 FIND v(xdut.n_xarray/xi15/xi9/net2_xarray/xi15/xi9/mm0_g) AT=34.900000000n
.measure tran f15c02 FIND v(xdut.n_xarray/xi15/xi13/net2_xarray/xi15/xi13/mm0_g) AT=34.900000000n
.measure tran f15c03 FIND v(xdut.n_xarray/xi15/xi17/net2_xarray/xi15/xi17/mm0_g) AT=34.900000000n
.measure tran f15c04 FIND v(xdut.n_xarray/xi15/xi21/net2_xarray/xi15/xi21/mm0_g) AT=34.900000000n
.measure tran f15c05 FIND v(xdut.n_xarray/xi15/xi25/net2_xarray/xi15/xi25/mm0_g) AT=34.900000000n
.measure tran f15c06 FIND v(xdut.n_xarray/xi15/xi29/net2_xarray/xi15/xi29/mm0_g) AT=34.900000000n
.measure tran f15c07 FIND v(xdut.n_xarray/xi15/xi33/net2_xarray/xi15/xi33/mm0_g) AT=34.900000000n
.measure tran f15c08 FIND v(xdut.n_xarray/xi15/xi6/net2_xarray/xi15/xi6/mm0_g) AT=34.900000000n
.measure tran f15c09 FIND v(xdut.n_xarray/xi15/xi10/net2_xarray/xi15/xi10/mm0_g) AT=34.900000000n
.measure tran f15c10 FIND v(xdut.n_xarray/xi15/xi14/net2_xarray/xi15/xi14/mm0_g) AT=34.900000000n
.measure tran f15c11 FIND v(xdut.n_xarray/xi15/xi18/net2_xarray/xi15/xi18/mm0_g) AT=34.900000000n
.measure tran f15c12 FIND v(xdut.n_xarray/xi15/xi22/net2_xarray/xi15/xi22/mm0_g) AT=34.900000000n
.measure tran f15c13 FIND v(xdut.n_xarray/xi15/xi26/net2_xarray/xi15/xi26/mm0_g) AT=34.900000000n
.measure tran f15c14 FIND v(xdut.n_xarray/xi15/xi30/net2_xarray/xi15/xi30/mm0_g) AT=34.900000000n
.measure tran f15c15 FIND v(xdut.n_xarray/xi15/xi34/net2_xarray/xi15/xi34/mm0_g) AT=34.900000000n
.measure tran f15c16 FIND v(xdut.n_xarray/xi15/xi7/net2_xarray/xi15/xi7/mm0_g) AT=34.900000000n
.measure tran f15c17 FIND v(xdut.n_xarray/xi15/xi11/net2_xarray/xi15/xi11/mm0_g) AT=34.900000000n
.measure tran f15c18 FIND v(xdut.n_xarray/xi15/xi15/net2_xarray/xi15/xi15/mm0_g) AT=34.900000000n
.measure tran f15c19 FIND v(xdut.n_xarray/xi15/xi19/net2_xarray/xi15/xi19/mm0_g) AT=34.900000000n
.measure tran f15c20 FIND v(xdut.n_xarray/xi15/xi23/net2_xarray/xi15/xi23/mm0_g) AT=34.900000000n
.measure tran f15c21 FIND v(xdut.n_xarray/xi15/xi27/net2_xarray/xi15/xi27/mm0_g) AT=34.900000000n
.measure tran f15c22 FIND v(xdut.n_xarray/xi15/xi31/net2_xarray/xi15/xi31/mm0_g) AT=34.900000000n
.measure tran f15c23 FIND v(xdut.n_xarray/xi15/xi35/net2_xarray/xi15/xi35/mm0_g) AT=34.900000000n
.measure tran f15c24 FIND v(xdut.n_xarray/xi15/xi8/net2_xarray/xi15/xi8/mm0_g) AT=34.900000000n
.measure tran f15c25 FIND v(xdut.n_xarray/xi15/xi12/net2_xarray/xi15/xi12/mm0_g) AT=34.900000000n
.measure tran f15c26 FIND v(xdut.n_xarray/xi15/xi16/net2_xarray/xi15/xi16/mm0_g) AT=34.900000000n
.measure tran f15c27 FIND v(xdut.n_xarray/xi15/xi20/net2_xarray/xi15/xi20/mm0_g) AT=34.900000000n
.measure tran f15c28 FIND v(xdut.n_xarray/xi15/xi24/net2_xarray/xi15/xi24/mm0_g) AT=34.900000000n
.measure tran f15c29 FIND v(xdut.n_xarray/xi15/xi28/net2_xarray/xi15/xi28/mm0_g) AT=34.900000000n
.measure tran f15c30 FIND v(xdut.n_xarray/xi15/xi32/net2_xarray/xi15/xi32/mm0_g) AT=34.900000000n
.measure tran f15c31 FIND v(xdut.n_xarray/xi15/xi36/net2_xarray/xi15/xi36/mm0_g) AT=34.900000000n
.measure tran h000w00 FIND v(xdut.n_wl<0>_xarray/xi0/xi36/mm5_g) AT=2.300000000n
.measure tran h000w01 FIND v(xdut.n_wl<1>_xarray/xi1/xi36/mm5_g) AT=2.300000000n
.measure tran h000w02 FIND v(xdut.n_wl<2>_xarray/xi2/xi36/mm5_g) AT=2.300000000n
.measure tran h000w03 FIND v(xdut.n_wl<3>_xarray/xi3/xi36/mm5_g) AT=2.300000000n
.measure tran h000w04 FIND v(xdut.n_wl<4>_xarray/xi4/xi36/mm5_g) AT=2.300000000n
.measure tran h000w05 FIND v(xdut.n_wl<5>_xarray/xi5/xi36/mm5_g) AT=2.300000000n
.measure tran h000w06 FIND v(xdut.n_wl<6>_xarray/xi6/xi36/mm5_g) AT=2.300000000n
.measure tran h000w07 FIND v(xdut.n_wl<7>_xarray/xi7/xi36/mm5_g) AT=2.300000000n
.measure tran h000w08 FIND v(xdut.n_wl<8>_xarray/xi8/xi36/mm5_g) AT=2.300000000n
.measure tran h000w09 FIND v(xdut.n_wl<9>_xarray/xi9/xi36/mm5_g) AT=2.300000000n
.measure tran h000w10 FIND v(xdut.n_wl<10>_xarray/xi10/xi36/mm5_g) AT=2.300000000n
.measure tran h000w11 FIND v(xdut.n_wl<11>_xarray/xi11/xi36/mm5_g) AT=2.300000000n
.measure tran h000w12 FIND v(xdut.n_wl<12>_xarray/xi12/xi36/mm5_g) AT=2.300000000n
.measure tran h000w13 FIND v(xdut.n_wl<13>_xarray/xi13/xi36/mm5_g) AT=2.300000000n
.measure tran h000w14 FIND v(xdut.n_wl<14>_xarray/xi14/xi36/mm5_g) AT=2.300000000n
.measure tran h000w15 FIND v(xdut.n_wl<15>_xarray/xi15/xi36/mm5_g) AT=2.300000000n
.measure tran l000 FIND v(xdut.n_wl<0>_xarray/xi0/xi36/mm5_g) AT=2.940000000n
.measure tran h001w00 FIND v(xdut.n_wl<0>_xarray/xi0/xi36/mm5_g) AT=3.300000000n
.measure tran h001w01 FIND v(xdut.n_wl<1>_xarray/xi1/xi36/mm5_g) AT=3.300000000n
.measure tran h001w02 FIND v(xdut.n_wl<2>_xarray/xi2/xi36/mm5_g) AT=3.300000000n
.measure tran h001w03 FIND v(xdut.n_wl<3>_xarray/xi3/xi36/mm5_g) AT=3.300000000n
.measure tran h001w04 FIND v(xdut.n_wl<4>_xarray/xi4/xi36/mm5_g) AT=3.300000000n
.measure tran h001w05 FIND v(xdut.n_wl<5>_xarray/xi5/xi36/mm5_g) AT=3.300000000n
.measure tran h001w06 FIND v(xdut.n_wl<6>_xarray/xi6/xi36/mm5_g) AT=3.300000000n
.measure tran h001w07 FIND v(xdut.n_wl<7>_xarray/xi7/xi36/mm5_g) AT=3.300000000n
.measure tran h001w08 FIND v(xdut.n_wl<8>_xarray/xi8/xi36/mm5_g) AT=3.300000000n
.measure tran h001w09 FIND v(xdut.n_wl<9>_xarray/xi9/xi36/mm5_g) AT=3.300000000n
.measure tran h001w10 FIND v(xdut.n_wl<10>_xarray/xi10/xi36/mm5_g) AT=3.300000000n
.measure tran h001w11 FIND v(xdut.n_wl<11>_xarray/xi11/xi36/mm5_g) AT=3.300000000n
.measure tran h001w12 FIND v(xdut.n_wl<12>_xarray/xi12/xi36/mm5_g) AT=3.300000000n
.measure tran h001w13 FIND v(xdut.n_wl<13>_xarray/xi13/xi36/mm5_g) AT=3.300000000n
.measure tran h001w14 FIND v(xdut.n_wl<14>_xarray/xi14/xi36/mm5_g) AT=3.300000000n
.measure tran h001w15 FIND v(xdut.n_wl<15>_xarray/xi15/xi36/mm5_g) AT=3.300000000n
.measure tran l001 FIND v(xdut.n_wl<0>_xarray/xi0/xi36/mm5_g) AT=3.940000000n
.measure tran h002w00 FIND v(xdut.n_wl<0>_xarray/xi0/xi36/mm5_g) AT=4.300000000n
.measure tran h002w01 FIND v(xdut.n_wl<1>_xarray/xi1/xi36/mm5_g) AT=4.300000000n
.measure tran h002w02 FIND v(xdut.n_wl<2>_xarray/xi2/xi36/mm5_g) AT=4.300000000n
.measure tran h002w03 FIND v(xdut.n_wl<3>_xarray/xi3/xi36/mm5_g) AT=4.300000000n
.measure tran h002w04 FIND v(xdut.n_wl<4>_xarray/xi4/xi36/mm5_g) AT=4.300000000n
.measure tran h002w05 FIND v(xdut.n_wl<5>_xarray/xi5/xi36/mm5_g) AT=4.300000000n
.measure tran h002w06 FIND v(xdut.n_wl<6>_xarray/xi6/xi36/mm5_g) AT=4.300000000n
.measure tran h002w07 FIND v(xdut.n_wl<7>_xarray/xi7/xi36/mm5_g) AT=4.300000000n
.measure tran h002w08 FIND v(xdut.n_wl<8>_xarray/xi8/xi36/mm5_g) AT=4.300000000n
.measure tran h002w09 FIND v(xdut.n_wl<9>_xarray/xi9/xi36/mm5_g) AT=4.300000000n
.measure tran h002w10 FIND v(xdut.n_wl<10>_xarray/xi10/xi36/mm5_g) AT=4.300000000n
.measure tran h002w11 FIND v(xdut.n_wl<11>_xarray/xi11/xi36/mm5_g) AT=4.300000000n
.measure tran h002w12 FIND v(xdut.n_wl<12>_xarray/xi12/xi36/mm5_g) AT=4.300000000n
.measure tran h002w13 FIND v(xdut.n_wl<13>_xarray/xi13/xi36/mm5_g) AT=4.300000000n
.measure tran h002w14 FIND v(xdut.n_wl<14>_xarray/xi14/xi36/mm5_g) AT=4.300000000n
.measure tran h002w15 FIND v(xdut.n_wl<15>_xarray/xi15/xi36/mm5_g) AT=4.300000000n
.measure tran l002 FIND v(xdut.n_wl<0>_xarray/xi0/xi36/mm5_g) AT=4.940000000n
.measure tran h003w00 FIND v(xdut.n_wl<0>_xarray/xi0/xi36/mm5_g) AT=5.300000000n
.measure tran h003w01 FIND v(xdut.n_wl<1>_xarray/xi1/xi36/mm5_g) AT=5.300000000n
.measure tran h003w02 FIND v(xdut.n_wl<2>_xarray/xi2/xi36/mm5_g) AT=5.300000000n
.measure tran h003w03 FIND v(xdut.n_wl<3>_xarray/xi3/xi36/mm5_g) AT=5.300000000n
.measure tran h003w04 FIND v(xdut.n_wl<4>_xarray/xi4/xi36/mm5_g) AT=5.300000000n
.measure tran h003w05 FIND v(xdut.n_wl<5>_xarray/xi5/xi36/mm5_g) AT=5.300000000n
.measure tran h003w06 FIND v(xdut.n_wl<6>_xarray/xi6/xi36/mm5_g) AT=5.300000000n
.measure tran h003w07 FIND v(xdut.n_wl<7>_xarray/xi7/xi36/mm5_g) AT=5.300000000n
.measure tran h003w08 FIND v(xdut.n_wl<8>_xarray/xi8/xi36/mm5_g) AT=5.300000000n
.measure tran h003w09 FIND v(xdut.n_wl<9>_xarray/xi9/xi36/mm5_g) AT=5.300000000n
.measure tran h003w10 FIND v(xdut.n_wl<10>_xarray/xi10/xi36/mm5_g) AT=5.300000000n
.measure tran h003w11 FIND v(xdut.n_wl<11>_xarray/xi11/xi36/mm5_g) AT=5.300000000n
.measure tran h003w12 FIND v(xdut.n_wl<12>_xarray/xi12/xi36/mm5_g) AT=5.300000000n
.measure tran h003w13 FIND v(xdut.n_wl<13>_xarray/xi13/xi36/mm5_g) AT=5.300000000n
.measure tran h003w14 FIND v(xdut.n_wl<14>_xarray/xi14/xi36/mm5_g) AT=5.300000000n
.measure tran h003w15 FIND v(xdut.n_wl<15>_xarray/xi15/xi36/mm5_g) AT=5.300000000n
.measure tran l003 FIND v(xdut.n_wl<0>_xarray/xi0/xi36/mm5_g) AT=5.940000000n
.measure tran h004w00 FIND v(xdut.n_wl<0>_xarray/xi0/xi36/mm5_g) AT=6.300000000n
.measure tran h004w01 FIND v(xdut.n_wl<1>_xarray/xi1/xi36/mm5_g) AT=6.300000000n
.measure tran h004w02 FIND v(xdut.n_wl<2>_xarray/xi2/xi36/mm5_g) AT=6.300000000n
.measure tran h004w03 FIND v(xdut.n_wl<3>_xarray/xi3/xi36/mm5_g) AT=6.300000000n
.measure tran h004w04 FIND v(xdut.n_wl<4>_xarray/xi4/xi36/mm5_g) AT=6.300000000n
.measure tran h004w05 FIND v(xdut.n_wl<5>_xarray/xi5/xi36/mm5_g) AT=6.300000000n
.measure tran h004w06 FIND v(xdut.n_wl<6>_xarray/xi6/xi36/mm5_g) AT=6.300000000n
.measure tran h004w07 FIND v(xdut.n_wl<7>_xarray/xi7/xi36/mm5_g) AT=6.300000000n
.measure tran h004w08 FIND v(xdut.n_wl<8>_xarray/xi8/xi36/mm5_g) AT=6.300000000n
.measure tran h004w09 FIND v(xdut.n_wl<9>_xarray/xi9/xi36/mm5_g) AT=6.300000000n
.measure tran h004w10 FIND v(xdut.n_wl<10>_xarray/xi10/xi36/mm5_g) AT=6.300000000n
.measure tran h004w11 FIND v(xdut.n_wl<11>_xarray/xi11/xi36/mm5_g) AT=6.300000000n
.measure tran h004w12 FIND v(xdut.n_wl<12>_xarray/xi12/xi36/mm5_g) AT=6.300000000n
.measure tran h004w13 FIND v(xdut.n_wl<13>_xarray/xi13/xi36/mm5_g) AT=6.300000000n
.measure tran h004w14 FIND v(xdut.n_wl<14>_xarray/xi14/xi36/mm5_g) AT=6.300000000n
.measure tran h004w15 FIND v(xdut.n_wl<15>_xarray/xi15/xi36/mm5_g) AT=6.300000000n
.measure tran l004 FIND v(xdut.n_wl<0>_xarray/xi0/xi36/mm5_g) AT=6.940000000n
.measure tran h005w00 FIND v(xdut.n_wl<0>_xarray/xi0/xi36/mm5_g) AT=7.300000000n
.measure tran h005w01 FIND v(xdut.n_wl<1>_xarray/xi1/xi36/mm5_g) AT=7.300000000n
.measure tran h005w02 FIND v(xdut.n_wl<2>_xarray/xi2/xi36/mm5_g) AT=7.300000000n
.measure tran h005w03 FIND v(xdut.n_wl<3>_xarray/xi3/xi36/mm5_g) AT=7.300000000n
.measure tran h005w04 FIND v(xdut.n_wl<4>_xarray/xi4/xi36/mm5_g) AT=7.300000000n
.measure tran h005w05 FIND v(xdut.n_wl<5>_xarray/xi5/xi36/mm5_g) AT=7.300000000n
.measure tran h005w06 FIND v(xdut.n_wl<6>_xarray/xi6/xi36/mm5_g) AT=7.300000000n
.measure tran h005w07 FIND v(xdut.n_wl<7>_xarray/xi7/xi36/mm5_g) AT=7.300000000n
.measure tran h005w08 FIND v(xdut.n_wl<8>_xarray/xi8/xi36/mm5_g) AT=7.300000000n
.measure tran h005w09 FIND v(xdut.n_wl<9>_xarray/xi9/xi36/mm5_g) AT=7.300000000n
.measure tran h005w10 FIND v(xdut.n_wl<10>_xarray/xi10/xi36/mm5_g) AT=7.300000000n
.measure tran h005w11 FIND v(xdut.n_wl<11>_xarray/xi11/xi36/mm5_g) AT=7.300000000n
.measure tran h005w12 FIND v(xdut.n_wl<12>_xarray/xi12/xi36/mm5_g) AT=7.300000000n
.measure tran h005w13 FIND v(xdut.n_wl<13>_xarray/xi13/xi36/mm5_g) AT=7.300000000n
.measure tran h005w14 FIND v(xdut.n_wl<14>_xarray/xi14/xi36/mm5_g) AT=7.300000000n
.measure tran h005w15 FIND v(xdut.n_wl<15>_xarray/xi15/xi36/mm5_g) AT=7.300000000n
.measure tran l005 FIND v(xdut.n_wl<0>_xarray/xi0/xi36/mm5_g) AT=7.940000000n
.measure tran h006w00 FIND v(xdut.n_wl<0>_xarray/xi0/xi36/mm5_g) AT=8.300000000n
.measure tran h006w01 FIND v(xdut.n_wl<1>_xarray/xi1/xi36/mm5_g) AT=8.300000000n
.measure tran h006w02 FIND v(xdut.n_wl<2>_xarray/xi2/xi36/mm5_g) AT=8.300000000n
.measure tran h006w03 FIND v(xdut.n_wl<3>_xarray/xi3/xi36/mm5_g) AT=8.300000000n
.measure tran h006w04 FIND v(xdut.n_wl<4>_xarray/xi4/xi36/mm5_g) AT=8.300000000n
.measure tran h006w05 FIND v(xdut.n_wl<5>_xarray/xi5/xi36/mm5_g) AT=8.300000000n
.measure tran h006w06 FIND v(xdut.n_wl<6>_xarray/xi6/xi36/mm5_g) AT=8.300000000n
.measure tran h006w07 FIND v(xdut.n_wl<7>_xarray/xi7/xi36/mm5_g) AT=8.300000000n
.measure tran h006w08 FIND v(xdut.n_wl<8>_xarray/xi8/xi36/mm5_g) AT=8.300000000n
.measure tran h006w09 FIND v(xdut.n_wl<9>_xarray/xi9/xi36/mm5_g) AT=8.300000000n
.measure tran h006w10 FIND v(xdut.n_wl<10>_xarray/xi10/xi36/mm5_g) AT=8.300000000n
.measure tran h006w11 FIND v(xdut.n_wl<11>_xarray/xi11/xi36/mm5_g) AT=8.300000000n
.measure tran h006w12 FIND v(xdut.n_wl<12>_xarray/xi12/xi36/mm5_g) AT=8.300000000n
.measure tran h006w13 FIND v(xdut.n_wl<13>_xarray/xi13/xi36/mm5_g) AT=8.300000000n
.measure tran h006w14 FIND v(xdut.n_wl<14>_xarray/xi14/xi36/mm5_g) AT=8.300000000n
.measure tran h006w15 FIND v(xdut.n_wl<15>_xarray/xi15/xi36/mm5_g) AT=8.300000000n
.measure tran l006 FIND v(xdut.n_wl<0>_xarray/xi0/xi36/mm5_g) AT=8.940000000n
.measure tran h007w00 FIND v(xdut.n_wl<0>_xarray/xi0/xi36/mm5_g) AT=9.300000000n
.measure tran h007w01 FIND v(xdut.n_wl<1>_xarray/xi1/xi36/mm5_g) AT=9.300000000n
.measure tran h007w02 FIND v(xdut.n_wl<2>_xarray/xi2/xi36/mm5_g) AT=9.300000000n
.measure tran h007w03 FIND v(xdut.n_wl<3>_xarray/xi3/xi36/mm5_g) AT=9.300000000n
.measure tran h007w04 FIND v(xdut.n_wl<4>_xarray/xi4/xi36/mm5_g) AT=9.300000000n
.measure tran h007w05 FIND v(xdut.n_wl<5>_xarray/xi5/xi36/mm5_g) AT=9.300000000n
.measure tran h007w06 FIND v(xdut.n_wl<6>_xarray/xi6/xi36/mm5_g) AT=9.300000000n
.measure tran h007w07 FIND v(xdut.n_wl<7>_xarray/xi7/xi36/mm5_g) AT=9.300000000n
.measure tran h007w08 FIND v(xdut.n_wl<8>_xarray/xi8/xi36/mm5_g) AT=9.300000000n
.measure tran h007w09 FIND v(xdut.n_wl<9>_xarray/xi9/xi36/mm5_g) AT=9.300000000n
.measure tran h007w10 FIND v(xdut.n_wl<10>_xarray/xi10/xi36/mm5_g) AT=9.300000000n
.measure tran h007w11 FIND v(xdut.n_wl<11>_xarray/xi11/xi36/mm5_g) AT=9.300000000n
.measure tran h007w12 FIND v(xdut.n_wl<12>_xarray/xi12/xi36/mm5_g) AT=9.300000000n
.measure tran h007w13 FIND v(xdut.n_wl<13>_xarray/xi13/xi36/mm5_g) AT=9.300000000n
.measure tran h007w14 FIND v(xdut.n_wl<14>_xarray/xi14/xi36/mm5_g) AT=9.300000000n
.measure tran h007w15 FIND v(xdut.n_wl<15>_xarray/xi15/xi36/mm5_g) AT=9.300000000n
.measure tran l007 FIND v(xdut.n_wl<0>_xarray/xi0/xi36/mm5_g) AT=9.940000000n
.measure tran h008w00 FIND v(xdut.n_wl<0>_xarray/xi0/xi36/mm5_g) AT=10.300000000n
.measure tran h008w01 FIND v(xdut.n_wl<1>_xarray/xi1/xi36/mm5_g) AT=10.300000000n
.measure tran h008w02 FIND v(xdut.n_wl<2>_xarray/xi2/xi36/mm5_g) AT=10.300000000n
.measure tran h008w03 FIND v(xdut.n_wl<3>_xarray/xi3/xi36/mm5_g) AT=10.300000000n
.measure tran h008w04 FIND v(xdut.n_wl<4>_xarray/xi4/xi36/mm5_g) AT=10.300000000n
.measure tran h008w05 FIND v(xdut.n_wl<5>_xarray/xi5/xi36/mm5_g) AT=10.300000000n
.measure tran h008w06 FIND v(xdut.n_wl<6>_xarray/xi6/xi36/mm5_g) AT=10.300000000n
.measure tran h008w07 FIND v(xdut.n_wl<7>_xarray/xi7/xi36/mm5_g) AT=10.300000000n
.measure tran h008w08 FIND v(xdut.n_wl<8>_xarray/xi8/xi36/mm5_g) AT=10.300000000n
.measure tran h008w09 FIND v(xdut.n_wl<9>_xarray/xi9/xi36/mm5_g) AT=10.300000000n
.measure tran h008w10 FIND v(xdut.n_wl<10>_xarray/xi10/xi36/mm5_g) AT=10.300000000n
.measure tran h008w11 FIND v(xdut.n_wl<11>_xarray/xi11/xi36/mm5_g) AT=10.300000000n
.measure tran h008w12 FIND v(xdut.n_wl<12>_xarray/xi12/xi36/mm5_g) AT=10.300000000n
.measure tran h008w13 FIND v(xdut.n_wl<13>_xarray/xi13/xi36/mm5_g) AT=10.300000000n
.measure tran h008w14 FIND v(xdut.n_wl<14>_xarray/xi14/xi36/mm5_g) AT=10.300000000n
.measure tran h008w15 FIND v(xdut.n_wl<15>_xarray/xi15/xi36/mm5_g) AT=10.300000000n
.measure tran l008 FIND v(xdut.n_wl<15>_xarray/xi15/xi36/mm5_g) AT=10.940000000n
.measure tran h009w00 FIND v(xdut.n_wl<0>_xarray/xi0/xi36/mm5_g) AT=11.300000000n
.measure tran h009w01 FIND v(xdut.n_wl<1>_xarray/xi1/xi36/mm5_g) AT=11.300000000n
.measure tran h009w02 FIND v(xdut.n_wl<2>_xarray/xi2/xi36/mm5_g) AT=11.300000000n
.measure tran h009w03 FIND v(xdut.n_wl<3>_xarray/xi3/xi36/mm5_g) AT=11.300000000n
.measure tran h009w04 FIND v(xdut.n_wl<4>_xarray/xi4/xi36/mm5_g) AT=11.300000000n
.measure tran h009w05 FIND v(xdut.n_wl<5>_xarray/xi5/xi36/mm5_g) AT=11.300000000n
.measure tran h009w06 FIND v(xdut.n_wl<6>_xarray/xi6/xi36/mm5_g) AT=11.300000000n
.measure tran h009w07 FIND v(xdut.n_wl<7>_xarray/xi7/xi36/mm5_g) AT=11.300000000n
.measure tran h009w08 FIND v(xdut.n_wl<8>_xarray/xi8/xi36/mm5_g) AT=11.300000000n
.measure tran h009w09 FIND v(xdut.n_wl<9>_xarray/xi9/xi36/mm5_g) AT=11.300000000n
.measure tran h009w10 FIND v(xdut.n_wl<10>_xarray/xi10/xi36/mm5_g) AT=11.300000000n
.measure tran h009w11 FIND v(xdut.n_wl<11>_xarray/xi11/xi36/mm5_g) AT=11.300000000n
.measure tran h009w12 FIND v(xdut.n_wl<12>_xarray/xi12/xi36/mm5_g) AT=11.300000000n
.measure tran h009w13 FIND v(xdut.n_wl<13>_xarray/xi13/xi36/mm5_g) AT=11.300000000n
.measure tran h009w14 FIND v(xdut.n_wl<14>_xarray/xi14/xi36/mm5_g) AT=11.300000000n
.measure tran h009w15 FIND v(xdut.n_wl<15>_xarray/xi15/xi36/mm5_g) AT=11.300000000n
.measure tran l009 FIND v(xdut.n_wl<15>_xarray/xi15/xi36/mm5_g) AT=11.940000000n
.measure tran h010w00 FIND v(xdut.n_wl<0>_xarray/xi0/xi36/mm5_g) AT=12.300000000n
.measure tran h010w01 FIND v(xdut.n_wl<1>_xarray/xi1/xi36/mm5_g) AT=12.300000000n
.measure tran h010w02 FIND v(xdut.n_wl<2>_xarray/xi2/xi36/mm5_g) AT=12.300000000n
.measure tran h010w03 FIND v(xdut.n_wl<3>_xarray/xi3/xi36/mm5_g) AT=12.300000000n
.measure tran h010w04 FIND v(xdut.n_wl<4>_xarray/xi4/xi36/mm5_g) AT=12.300000000n
.measure tran h010w05 FIND v(xdut.n_wl<5>_xarray/xi5/xi36/mm5_g) AT=12.300000000n
.measure tran h010w06 FIND v(xdut.n_wl<6>_xarray/xi6/xi36/mm5_g) AT=12.300000000n
.measure tran h010w07 FIND v(xdut.n_wl<7>_xarray/xi7/xi36/mm5_g) AT=12.300000000n
.measure tran h010w08 FIND v(xdut.n_wl<8>_xarray/xi8/xi36/mm5_g) AT=12.300000000n
.measure tran h010w09 FIND v(xdut.n_wl<9>_xarray/xi9/xi36/mm5_g) AT=12.300000000n
.measure tran h010w10 FIND v(xdut.n_wl<10>_xarray/xi10/xi36/mm5_g) AT=12.300000000n
.measure tran h010w11 FIND v(xdut.n_wl<11>_xarray/xi11/xi36/mm5_g) AT=12.300000000n
.measure tran h010w12 FIND v(xdut.n_wl<12>_xarray/xi12/xi36/mm5_g) AT=12.300000000n
.measure tran h010w13 FIND v(xdut.n_wl<13>_xarray/xi13/xi36/mm5_g) AT=12.300000000n
.measure tran h010w14 FIND v(xdut.n_wl<14>_xarray/xi14/xi36/mm5_g) AT=12.300000000n
.measure tran h010w15 FIND v(xdut.n_wl<15>_xarray/xi15/xi36/mm5_g) AT=12.300000000n
.measure tran l010 FIND v(xdut.n_wl<15>_xarray/xi15/xi36/mm5_g) AT=12.940000000n
.measure tran h011w00 FIND v(xdut.n_wl<0>_xarray/xi0/xi36/mm5_g) AT=13.300000000n
.measure tran h011w01 FIND v(xdut.n_wl<1>_xarray/xi1/xi36/mm5_g) AT=13.300000000n
.measure tran h011w02 FIND v(xdut.n_wl<2>_xarray/xi2/xi36/mm5_g) AT=13.300000000n
.measure tran h011w03 FIND v(xdut.n_wl<3>_xarray/xi3/xi36/mm5_g) AT=13.300000000n
.measure tran h011w04 FIND v(xdut.n_wl<4>_xarray/xi4/xi36/mm5_g) AT=13.300000000n
.measure tran h011w05 FIND v(xdut.n_wl<5>_xarray/xi5/xi36/mm5_g) AT=13.300000000n
.measure tran h011w06 FIND v(xdut.n_wl<6>_xarray/xi6/xi36/mm5_g) AT=13.300000000n
.measure tran h011w07 FIND v(xdut.n_wl<7>_xarray/xi7/xi36/mm5_g) AT=13.300000000n
.measure tran h011w08 FIND v(xdut.n_wl<8>_xarray/xi8/xi36/mm5_g) AT=13.300000000n
.measure tran h011w09 FIND v(xdut.n_wl<9>_xarray/xi9/xi36/mm5_g) AT=13.300000000n
.measure tran h011w10 FIND v(xdut.n_wl<10>_xarray/xi10/xi36/mm5_g) AT=13.300000000n
.measure tran h011w11 FIND v(xdut.n_wl<11>_xarray/xi11/xi36/mm5_g) AT=13.300000000n
.measure tran h011w12 FIND v(xdut.n_wl<12>_xarray/xi12/xi36/mm5_g) AT=13.300000000n
.measure tran h011w13 FIND v(xdut.n_wl<13>_xarray/xi13/xi36/mm5_g) AT=13.300000000n
.measure tran h011w14 FIND v(xdut.n_wl<14>_xarray/xi14/xi36/mm5_g) AT=13.300000000n
.measure tran h011w15 FIND v(xdut.n_wl<15>_xarray/xi15/xi36/mm5_g) AT=13.300000000n
.measure tran l011 FIND v(xdut.n_wl<15>_xarray/xi15/xi36/mm5_g) AT=13.940000000n
.measure tran h012w00 FIND v(xdut.n_wl<0>_xarray/xi0/xi36/mm5_g) AT=14.300000000n
.measure tran h012w01 FIND v(xdut.n_wl<1>_xarray/xi1/xi36/mm5_g) AT=14.300000000n
.measure tran h012w02 FIND v(xdut.n_wl<2>_xarray/xi2/xi36/mm5_g) AT=14.300000000n
.measure tran h012w03 FIND v(xdut.n_wl<3>_xarray/xi3/xi36/mm5_g) AT=14.300000000n
.measure tran h012w04 FIND v(xdut.n_wl<4>_xarray/xi4/xi36/mm5_g) AT=14.300000000n
.measure tran h012w05 FIND v(xdut.n_wl<5>_xarray/xi5/xi36/mm5_g) AT=14.300000000n
.measure tran h012w06 FIND v(xdut.n_wl<6>_xarray/xi6/xi36/mm5_g) AT=14.300000000n
.measure tran h012w07 FIND v(xdut.n_wl<7>_xarray/xi7/xi36/mm5_g) AT=14.300000000n
.measure tran h012w08 FIND v(xdut.n_wl<8>_xarray/xi8/xi36/mm5_g) AT=14.300000000n
.measure tran h012w09 FIND v(xdut.n_wl<9>_xarray/xi9/xi36/mm5_g) AT=14.300000000n
.measure tran h012w10 FIND v(xdut.n_wl<10>_xarray/xi10/xi36/mm5_g) AT=14.300000000n
.measure tran h012w11 FIND v(xdut.n_wl<11>_xarray/xi11/xi36/mm5_g) AT=14.300000000n
.measure tran h012w12 FIND v(xdut.n_wl<12>_xarray/xi12/xi36/mm5_g) AT=14.300000000n
.measure tran h012w13 FIND v(xdut.n_wl<13>_xarray/xi13/xi36/mm5_g) AT=14.300000000n
.measure tran h012w14 FIND v(xdut.n_wl<14>_xarray/xi14/xi36/mm5_g) AT=14.300000000n
.measure tran h012w15 FIND v(xdut.n_wl<15>_xarray/xi15/xi36/mm5_g) AT=14.300000000n
.measure tran l012 FIND v(xdut.n_wl<15>_xarray/xi15/xi36/mm5_g) AT=14.940000000n
.measure tran h013w00 FIND v(xdut.n_wl<0>_xarray/xi0/xi36/mm5_g) AT=15.300000000n
.measure tran h013w01 FIND v(xdut.n_wl<1>_xarray/xi1/xi36/mm5_g) AT=15.300000000n
.measure tran h013w02 FIND v(xdut.n_wl<2>_xarray/xi2/xi36/mm5_g) AT=15.300000000n
.measure tran h013w03 FIND v(xdut.n_wl<3>_xarray/xi3/xi36/mm5_g) AT=15.300000000n
.measure tran h013w04 FIND v(xdut.n_wl<4>_xarray/xi4/xi36/mm5_g) AT=15.300000000n
.measure tran h013w05 FIND v(xdut.n_wl<5>_xarray/xi5/xi36/mm5_g) AT=15.300000000n
.measure tran h013w06 FIND v(xdut.n_wl<6>_xarray/xi6/xi36/mm5_g) AT=15.300000000n
.measure tran h013w07 FIND v(xdut.n_wl<7>_xarray/xi7/xi36/mm5_g) AT=15.300000000n
.measure tran h013w08 FIND v(xdut.n_wl<8>_xarray/xi8/xi36/mm5_g) AT=15.300000000n
.measure tran h013w09 FIND v(xdut.n_wl<9>_xarray/xi9/xi36/mm5_g) AT=15.300000000n
.measure tran h013w10 FIND v(xdut.n_wl<10>_xarray/xi10/xi36/mm5_g) AT=15.300000000n
.measure tran h013w11 FIND v(xdut.n_wl<11>_xarray/xi11/xi36/mm5_g) AT=15.300000000n
.measure tran h013w12 FIND v(xdut.n_wl<12>_xarray/xi12/xi36/mm5_g) AT=15.300000000n
.measure tran h013w13 FIND v(xdut.n_wl<13>_xarray/xi13/xi36/mm5_g) AT=15.300000000n
.measure tran h013w14 FIND v(xdut.n_wl<14>_xarray/xi14/xi36/mm5_g) AT=15.300000000n
.measure tran h013w15 FIND v(xdut.n_wl<15>_xarray/xi15/xi36/mm5_g) AT=15.300000000n
.measure tran l013 FIND v(xdut.n_wl<15>_xarray/xi15/xi36/mm5_g) AT=15.940000000n
.measure tran h014w00 FIND v(xdut.n_wl<0>_xarray/xi0/xi36/mm5_g) AT=16.300000000n
.measure tran h014w01 FIND v(xdut.n_wl<1>_xarray/xi1/xi36/mm5_g) AT=16.300000000n
.measure tran h014w02 FIND v(xdut.n_wl<2>_xarray/xi2/xi36/mm5_g) AT=16.300000000n
.measure tran h014w03 FIND v(xdut.n_wl<3>_xarray/xi3/xi36/mm5_g) AT=16.300000000n
.measure tran h014w04 FIND v(xdut.n_wl<4>_xarray/xi4/xi36/mm5_g) AT=16.300000000n
.measure tran h014w05 FIND v(xdut.n_wl<5>_xarray/xi5/xi36/mm5_g) AT=16.300000000n
.measure tran h014w06 FIND v(xdut.n_wl<6>_xarray/xi6/xi36/mm5_g) AT=16.300000000n
.measure tran h014w07 FIND v(xdut.n_wl<7>_xarray/xi7/xi36/mm5_g) AT=16.300000000n
.measure tran h014w08 FIND v(xdut.n_wl<8>_xarray/xi8/xi36/mm5_g) AT=16.300000000n
.measure tran h014w09 FIND v(xdut.n_wl<9>_xarray/xi9/xi36/mm5_g) AT=16.300000000n
.measure tran h014w10 FIND v(xdut.n_wl<10>_xarray/xi10/xi36/mm5_g) AT=16.300000000n
.measure tran h014w11 FIND v(xdut.n_wl<11>_xarray/xi11/xi36/mm5_g) AT=16.300000000n
.measure tran h014w12 FIND v(xdut.n_wl<12>_xarray/xi12/xi36/mm5_g) AT=16.300000000n
.measure tran h014w13 FIND v(xdut.n_wl<13>_xarray/xi13/xi36/mm5_g) AT=16.300000000n
.measure tran h014w14 FIND v(xdut.n_wl<14>_xarray/xi14/xi36/mm5_g) AT=16.300000000n
.measure tran h014w15 FIND v(xdut.n_wl<15>_xarray/xi15/xi36/mm5_g) AT=16.300000000n
.measure tran l014 FIND v(xdut.n_wl<15>_xarray/xi15/xi36/mm5_g) AT=16.940000000n
.measure tran h015w00 FIND v(xdut.n_wl<0>_xarray/xi0/xi36/mm5_g) AT=17.300000000n
.measure tran h015w01 FIND v(xdut.n_wl<1>_xarray/xi1/xi36/mm5_g) AT=17.300000000n
.measure tran h015w02 FIND v(xdut.n_wl<2>_xarray/xi2/xi36/mm5_g) AT=17.300000000n
.measure tran h015w03 FIND v(xdut.n_wl<3>_xarray/xi3/xi36/mm5_g) AT=17.300000000n
.measure tran h015w04 FIND v(xdut.n_wl<4>_xarray/xi4/xi36/mm5_g) AT=17.300000000n
.measure tran h015w05 FIND v(xdut.n_wl<5>_xarray/xi5/xi36/mm5_g) AT=17.300000000n
.measure tran h015w06 FIND v(xdut.n_wl<6>_xarray/xi6/xi36/mm5_g) AT=17.300000000n
.measure tran h015w07 FIND v(xdut.n_wl<7>_xarray/xi7/xi36/mm5_g) AT=17.300000000n
.measure tran h015w08 FIND v(xdut.n_wl<8>_xarray/xi8/xi36/mm5_g) AT=17.300000000n
.measure tran h015w09 FIND v(xdut.n_wl<9>_xarray/xi9/xi36/mm5_g) AT=17.300000000n
.measure tran h015w10 FIND v(xdut.n_wl<10>_xarray/xi10/xi36/mm5_g) AT=17.300000000n
.measure tran h015w11 FIND v(xdut.n_wl<11>_xarray/xi11/xi36/mm5_g) AT=17.300000000n
.measure tran h015w12 FIND v(xdut.n_wl<12>_xarray/xi12/xi36/mm5_g) AT=17.300000000n
.measure tran h015w13 FIND v(xdut.n_wl<13>_xarray/xi13/xi36/mm5_g) AT=17.300000000n
.measure tran h015w14 FIND v(xdut.n_wl<14>_xarray/xi14/xi36/mm5_g) AT=17.300000000n
.measure tran h015w15 FIND v(xdut.n_wl<15>_xarray/xi15/xi36/mm5_g) AT=17.300000000n
.measure tran l015 FIND v(xdut.n_wl<15>_xarray/xi15/xi36/mm5_g) AT=17.940000000n
.measure tran h016w00 FIND v(xdut.n_wl<0>_xarray/xi0/xi36/mm5_g) AT=18.300000000n
.measure tran h016w01 FIND v(xdut.n_wl<1>_xarray/xi1/xi36/mm5_g) AT=18.300000000n
.measure tran h016w02 FIND v(xdut.n_wl<2>_xarray/xi2/xi36/mm5_g) AT=18.300000000n
.measure tran h016w03 FIND v(xdut.n_wl<3>_xarray/xi3/xi36/mm5_g) AT=18.300000000n
.measure tran h016w04 FIND v(xdut.n_wl<4>_xarray/xi4/xi36/mm5_g) AT=18.300000000n
.measure tran h016w05 FIND v(xdut.n_wl<5>_xarray/xi5/xi36/mm5_g) AT=18.300000000n
.measure tran h016w06 FIND v(xdut.n_wl<6>_xarray/xi6/xi36/mm5_g) AT=18.300000000n
.measure tran h016w07 FIND v(xdut.n_wl<7>_xarray/xi7/xi36/mm5_g) AT=18.300000000n
.measure tran h016w08 FIND v(xdut.n_wl<8>_xarray/xi8/xi36/mm5_g) AT=18.300000000n
.measure tran h016w09 FIND v(xdut.n_wl<9>_xarray/xi9/xi36/mm5_g) AT=18.300000000n
.measure tran h016w10 FIND v(xdut.n_wl<10>_xarray/xi10/xi36/mm5_g) AT=18.300000000n
.measure tran h016w11 FIND v(xdut.n_wl<11>_xarray/xi11/xi36/mm5_g) AT=18.300000000n
.measure tran h016w12 FIND v(xdut.n_wl<12>_xarray/xi12/xi36/mm5_g) AT=18.300000000n
.measure tran h016w13 FIND v(xdut.n_wl<13>_xarray/xi13/xi36/mm5_g) AT=18.300000000n
.measure tran h016w14 FIND v(xdut.n_wl<14>_xarray/xi14/xi36/mm5_g) AT=18.300000000n
.measure tran h016w15 FIND v(xdut.n_wl<15>_xarray/xi15/xi36/mm5_g) AT=18.300000000n
.measure tran l016 FIND v(xdut.n_wl<0>_xarray/xi0/xi36/mm5_g) AT=18.940000000n
.measure tran h017w00 FIND v(xdut.n_wl<0>_xarray/xi0/xi36/mm5_g) AT=19.300000000n
.measure tran h017w01 FIND v(xdut.n_wl<1>_xarray/xi1/xi36/mm5_g) AT=19.300000000n
.measure tran h017w02 FIND v(xdut.n_wl<2>_xarray/xi2/xi36/mm5_g) AT=19.300000000n
.measure tran h017w03 FIND v(xdut.n_wl<3>_xarray/xi3/xi36/mm5_g) AT=19.300000000n
.measure tran h017w04 FIND v(xdut.n_wl<4>_xarray/xi4/xi36/mm5_g) AT=19.300000000n
.measure tran h017w05 FIND v(xdut.n_wl<5>_xarray/xi5/xi36/mm5_g) AT=19.300000000n
.measure tran h017w06 FIND v(xdut.n_wl<6>_xarray/xi6/xi36/mm5_g) AT=19.300000000n
.measure tran h017w07 FIND v(xdut.n_wl<7>_xarray/xi7/xi36/mm5_g) AT=19.300000000n
.measure tran h017w08 FIND v(xdut.n_wl<8>_xarray/xi8/xi36/mm5_g) AT=19.300000000n
.measure tran h017w09 FIND v(xdut.n_wl<9>_xarray/xi9/xi36/mm5_g) AT=19.300000000n
.measure tran h017w10 FIND v(xdut.n_wl<10>_xarray/xi10/xi36/mm5_g) AT=19.300000000n
.measure tran h017w11 FIND v(xdut.n_wl<11>_xarray/xi11/xi36/mm5_g) AT=19.300000000n
.measure tran h017w12 FIND v(xdut.n_wl<12>_xarray/xi12/xi36/mm5_g) AT=19.300000000n
.measure tran h017w13 FIND v(xdut.n_wl<13>_xarray/xi13/xi36/mm5_g) AT=19.300000000n
.measure tran h017w14 FIND v(xdut.n_wl<14>_xarray/xi14/xi36/mm5_g) AT=19.300000000n
.measure tran h017w15 FIND v(xdut.n_wl<15>_xarray/xi15/xi36/mm5_g) AT=19.300000000n
.measure tran l017 FIND v(xdut.n_wl<0>_xarray/xi0/xi36/mm5_g) AT=19.940000000n
.measure tran h018w00 FIND v(xdut.n_wl<0>_xarray/xi0/xi36/mm5_g) AT=20.300000000n
.measure tran h018w01 FIND v(xdut.n_wl<1>_xarray/xi1/xi36/mm5_g) AT=20.300000000n
.measure tran h018w02 FIND v(xdut.n_wl<2>_xarray/xi2/xi36/mm5_g) AT=20.300000000n
.measure tran h018w03 FIND v(xdut.n_wl<3>_xarray/xi3/xi36/mm5_g) AT=20.300000000n
.measure tran h018w04 FIND v(xdut.n_wl<4>_xarray/xi4/xi36/mm5_g) AT=20.300000000n
.measure tran h018w05 FIND v(xdut.n_wl<5>_xarray/xi5/xi36/mm5_g) AT=20.300000000n
.measure tran h018w06 FIND v(xdut.n_wl<6>_xarray/xi6/xi36/mm5_g) AT=20.300000000n
.measure tran h018w07 FIND v(xdut.n_wl<7>_xarray/xi7/xi36/mm5_g) AT=20.300000000n
.measure tran h018w08 FIND v(xdut.n_wl<8>_xarray/xi8/xi36/mm5_g) AT=20.300000000n
.measure tran h018w09 FIND v(xdut.n_wl<9>_xarray/xi9/xi36/mm5_g) AT=20.300000000n
.measure tran h018w10 FIND v(xdut.n_wl<10>_xarray/xi10/xi36/mm5_g) AT=20.300000000n
.measure tran h018w11 FIND v(xdut.n_wl<11>_xarray/xi11/xi36/mm5_g) AT=20.300000000n
.measure tran h018w12 FIND v(xdut.n_wl<12>_xarray/xi12/xi36/mm5_g) AT=20.300000000n
.measure tran h018w13 FIND v(xdut.n_wl<13>_xarray/xi13/xi36/mm5_g) AT=20.300000000n
.measure tran h018w14 FIND v(xdut.n_wl<14>_xarray/xi14/xi36/mm5_g) AT=20.300000000n
.measure tran h018w15 FIND v(xdut.n_wl<15>_xarray/xi15/xi36/mm5_g) AT=20.300000000n
.measure tran l018 FIND v(xdut.n_wl<0>_xarray/xi0/xi36/mm5_g) AT=20.940000000n
.measure tran h019w00 FIND v(xdut.n_wl<0>_xarray/xi0/xi36/mm5_g) AT=21.300000000n
.measure tran h019w01 FIND v(xdut.n_wl<1>_xarray/xi1/xi36/mm5_g) AT=21.300000000n
.measure tran h019w02 FIND v(xdut.n_wl<2>_xarray/xi2/xi36/mm5_g) AT=21.300000000n
.measure tran h019w03 FIND v(xdut.n_wl<3>_xarray/xi3/xi36/mm5_g) AT=21.300000000n
.measure tran h019w04 FIND v(xdut.n_wl<4>_xarray/xi4/xi36/mm5_g) AT=21.300000000n
.measure tran h019w05 FIND v(xdut.n_wl<5>_xarray/xi5/xi36/mm5_g) AT=21.300000000n
.measure tran h019w06 FIND v(xdut.n_wl<6>_xarray/xi6/xi36/mm5_g) AT=21.300000000n
.measure tran h019w07 FIND v(xdut.n_wl<7>_xarray/xi7/xi36/mm5_g) AT=21.300000000n
.measure tran h019w08 FIND v(xdut.n_wl<8>_xarray/xi8/xi36/mm5_g) AT=21.300000000n
.measure tran h019w09 FIND v(xdut.n_wl<9>_xarray/xi9/xi36/mm5_g) AT=21.300000000n
.measure tran h019w10 FIND v(xdut.n_wl<10>_xarray/xi10/xi36/mm5_g) AT=21.300000000n
.measure tran h019w11 FIND v(xdut.n_wl<11>_xarray/xi11/xi36/mm5_g) AT=21.300000000n
.measure tran h019w12 FIND v(xdut.n_wl<12>_xarray/xi12/xi36/mm5_g) AT=21.300000000n
.measure tran h019w13 FIND v(xdut.n_wl<13>_xarray/xi13/xi36/mm5_g) AT=21.300000000n
.measure tran h019w14 FIND v(xdut.n_wl<14>_xarray/xi14/xi36/mm5_g) AT=21.300000000n
.measure tran h019w15 FIND v(xdut.n_wl<15>_xarray/xi15/xi36/mm5_g) AT=21.300000000n
.measure tran l019 FIND v(xdut.n_wl<0>_xarray/xi0/xi36/mm5_g) AT=21.940000000n
.measure tran h020w00 FIND v(xdut.n_wl<0>_xarray/xi0/xi36/mm5_g) AT=22.300000000n
.measure tran h020w01 FIND v(xdut.n_wl<1>_xarray/xi1/xi36/mm5_g) AT=22.300000000n
.measure tran h020w02 FIND v(xdut.n_wl<2>_xarray/xi2/xi36/mm5_g) AT=22.300000000n
.measure tran h020w03 FIND v(xdut.n_wl<3>_xarray/xi3/xi36/mm5_g) AT=22.300000000n
.measure tran h020w04 FIND v(xdut.n_wl<4>_xarray/xi4/xi36/mm5_g) AT=22.300000000n
.measure tran h020w05 FIND v(xdut.n_wl<5>_xarray/xi5/xi36/mm5_g) AT=22.300000000n
.measure tran h020w06 FIND v(xdut.n_wl<6>_xarray/xi6/xi36/mm5_g) AT=22.300000000n
.measure tran h020w07 FIND v(xdut.n_wl<7>_xarray/xi7/xi36/mm5_g) AT=22.300000000n
.measure tran h020w08 FIND v(xdut.n_wl<8>_xarray/xi8/xi36/mm5_g) AT=22.300000000n
.measure tran h020w09 FIND v(xdut.n_wl<9>_xarray/xi9/xi36/mm5_g) AT=22.300000000n
.measure tran h020w10 FIND v(xdut.n_wl<10>_xarray/xi10/xi36/mm5_g) AT=22.300000000n
.measure tran h020w11 FIND v(xdut.n_wl<11>_xarray/xi11/xi36/mm5_g) AT=22.300000000n
.measure tran h020w12 FIND v(xdut.n_wl<12>_xarray/xi12/xi36/mm5_g) AT=22.300000000n
.measure tran h020w13 FIND v(xdut.n_wl<13>_xarray/xi13/xi36/mm5_g) AT=22.300000000n
.measure tran h020w14 FIND v(xdut.n_wl<14>_xarray/xi14/xi36/mm5_g) AT=22.300000000n
.measure tran h020w15 FIND v(xdut.n_wl<15>_xarray/xi15/xi36/mm5_g) AT=22.300000000n
.measure tran l020 FIND v(xdut.n_wl<0>_xarray/xi0/xi36/mm5_g) AT=22.940000000n
.measure tran h021w00 FIND v(xdut.n_wl<0>_xarray/xi0/xi36/mm5_g) AT=23.300000000n
.measure tran h021w01 FIND v(xdut.n_wl<1>_xarray/xi1/xi36/mm5_g) AT=23.300000000n
.measure tran h021w02 FIND v(xdut.n_wl<2>_xarray/xi2/xi36/mm5_g) AT=23.300000000n
.measure tran h021w03 FIND v(xdut.n_wl<3>_xarray/xi3/xi36/mm5_g) AT=23.300000000n
.measure tran h021w04 FIND v(xdut.n_wl<4>_xarray/xi4/xi36/mm5_g) AT=23.300000000n
.measure tran h021w05 FIND v(xdut.n_wl<5>_xarray/xi5/xi36/mm5_g) AT=23.300000000n
.measure tran h021w06 FIND v(xdut.n_wl<6>_xarray/xi6/xi36/mm5_g) AT=23.300000000n
.measure tran h021w07 FIND v(xdut.n_wl<7>_xarray/xi7/xi36/mm5_g) AT=23.300000000n
.measure tran h021w08 FIND v(xdut.n_wl<8>_xarray/xi8/xi36/mm5_g) AT=23.300000000n
.measure tran h021w09 FIND v(xdut.n_wl<9>_xarray/xi9/xi36/mm5_g) AT=23.300000000n
.measure tran h021w10 FIND v(xdut.n_wl<10>_xarray/xi10/xi36/mm5_g) AT=23.300000000n
.measure tran h021w11 FIND v(xdut.n_wl<11>_xarray/xi11/xi36/mm5_g) AT=23.300000000n
.measure tran h021w12 FIND v(xdut.n_wl<12>_xarray/xi12/xi36/mm5_g) AT=23.300000000n
.measure tran h021w13 FIND v(xdut.n_wl<13>_xarray/xi13/xi36/mm5_g) AT=23.300000000n
.measure tran h021w14 FIND v(xdut.n_wl<14>_xarray/xi14/xi36/mm5_g) AT=23.300000000n
.measure tran h021w15 FIND v(xdut.n_wl<15>_xarray/xi15/xi36/mm5_g) AT=23.300000000n
.measure tran l021 FIND v(xdut.n_wl<0>_xarray/xi0/xi36/mm5_g) AT=23.940000000n
.measure tran h022w00 FIND v(xdut.n_wl<0>_xarray/xi0/xi36/mm5_g) AT=24.300000000n
.measure tran h022w01 FIND v(xdut.n_wl<1>_xarray/xi1/xi36/mm5_g) AT=24.300000000n
.measure tran h022w02 FIND v(xdut.n_wl<2>_xarray/xi2/xi36/mm5_g) AT=24.300000000n
.measure tran h022w03 FIND v(xdut.n_wl<3>_xarray/xi3/xi36/mm5_g) AT=24.300000000n
.measure tran h022w04 FIND v(xdut.n_wl<4>_xarray/xi4/xi36/mm5_g) AT=24.300000000n
.measure tran h022w05 FIND v(xdut.n_wl<5>_xarray/xi5/xi36/mm5_g) AT=24.300000000n
.measure tran h022w06 FIND v(xdut.n_wl<6>_xarray/xi6/xi36/mm5_g) AT=24.300000000n
.measure tran h022w07 FIND v(xdut.n_wl<7>_xarray/xi7/xi36/mm5_g) AT=24.300000000n
.measure tran h022w08 FIND v(xdut.n_wl<8>_xarray/xi8/xi36/mm5_g) AT=24.300000000n
.measure tran h022w09 FIND v(xdut.n_wl<9>_xarray/xi9/xi36/mm5_g) AT=24.300000000n
.measure tran h022w10 FIND v(xdut.n_wl<10>_xarray/xi10/xi36/mm5_g) AT=24.300000000n
.measure tran h022w11 FIND v(xdut.n_wl<11>_xarray/xi11/xi36/mm5_g) AT=24.300000000n
.measure tran h022w12 FIND v(xdut.n_wl<12>_xarray/xi12/xi36/mm5_g) AT=24.300000000n
.measure tran h022w13 FIND v(xdut.n_wl<13>_xarray/xi13/xi36/mm5_g) AT=24.300000000n
.measure tran h022w14 FIND v(xdut.n_wl<14>_xarray/xi14/xi36/mm5_g) AT=24.300000000n
.measure tran h022w15 FIND v(xdut.n_wl<15>_xarray/xi15/xi36/mm5_g) AT=24.300000000n
.measure tran l022 FIND v(xdut.n_wl<0>_xarray/xi0/xi36/mm5_g) AT=24.940000000n
.measure tran h023w00 FIND v(xdut.n_wl<0>_xarray/xi0/xi36/mm5_g) AT=25.300000000n
.measure tran h023w01 FIND v(xdut.n_wl<1>_xarray/xi1/xi36/mm5_g) AT=25.300000000n
.measure tran h023w02 FIND v(xdut.n_wl<2>_xarray/xi2/xi36/mm5_g) AT=25.300000000n
.measure tran h023w03 FIND v(xdut.n_wl<3>_xarray/xi3/xi36/mm5_g) AT=25.300000000n
.measure tran h023w04 FIND v(xdut.n_wl<4>_xarray/xi4/xi36/mm5_g) AT=25.300000000n
.measure tran h023w05 FIND v(xdut.n_wl<5>_xarray/xi5/xi36/mm5_g) AT=25.300000000n
.measure tran h023w06 FIND v(xdut.n_wl<6>_xarray/xi6/xi36/mm5_g) AT=25.300000000n
.measure tran h023w07 FIND v(xdut.n_wl<7>_xarray/xi7/xi36/mm5_g) AT=25.300000000n
.measure tran h023w08 FIND v(xdut.n_wl<8>_xarray/xi8/xi36/mm5_g) AT=25.300000000n
.measure tran h023w09 FIND v(xdut.n_wl<9>_xarray/xi9/xi36/mm5_g) AT=25.300000000n
.measure tran h023w10 FIND v(xdut.n_wl<10>_xarray/xi10/xi36/mm5_g) AT=25.300000000n
.measure tran h023w11 FIND v(xdut.n_wl<11>_xarray/xi11/xi36/mm5_g) AT=25.300000000n
.measure tran h023w12 FIND v(xdut.n_wl<12>_xarray/xi12/xi36/mm5_g) AT=25.300000000n
.measure tran h023w13 FIND v(xdut.n_wl<13>_xarray/xi13/xi36/mm5_g) AT=25.300000000n
.measure tran h023w14 FIND v(xdut.n_wl<14>_xarray/xi14/xi36/mm5_g) AT=25.300000000n
.measure tran h023w15 FIND v(xdut.n_wl<15>_xarray/xi15/xi36/mm5_g) AT=25.300000000n
.measure tran l023 FIND v(xdut.n_wl<0>_xarray/xi0/xi36/mm5_g) AT=25.940000000n
.measure tran h024w00 FIND v(xdut.n_wl<0>_xarray/xi0/xi36/mm5_g) AT=26.300000000n
.measure tran h024w01 FIND v(xdut.n_wl<1>_xarray/xi1/xi36/mm5_g) AT=26.300000000n
.measure tran h024w02 FIND v(xdut.n_wl<2>_xarray/xi2/xi36/mm5_g) AT=26.300000000n
.measure tran h024w03 FIND v(xdut.n_wl<3>_xarray/xi3/xi36/mm5_g) AT=26.300000000n
.measure tran h024w04 FIND v(xdut.n_wl<4>_xarray/xi4/xi36/mm5_g) AT=26.300000000n
.measure tran h024w05 FIND v(xdut.n_wl<5>_xarray/xi5/xi36/mm5_g) AT=26.300000000n
.measure tran h024w06 FIND v(xdut.n_wl<6>_xarray/xi6/xi36/mm5_g) AT=26.300000000n
.measure tran h024w07 FIND v(xdut.n_wl<7>_xarray/xi7/xi36/mm5_g) AT=26.300000000n
.measure tran h024w08 FIND v(xdut.n_wl<8>_xarray/xi8/xi36/mm5_g) AT=26.300000000n
.measure tran h024w09 FIND v(xdut.n_wl<9>_xarray/xi9/xi36/mm5_g) AT=26.300000000n
.measure tran h024w10 FIND v(xdut.n_wl<10>_xarray/xi10/xi36/mm5_g) AT=26.300000000n
.measure tran h024w11 FIND v(xdut.n_wl<11>_xarray/xi11/xi36/mm5_g) AT=26.300000000n
.measure tran h024w12 FIND v(xdut.n_wl<12>_xarray/xi12/xi36/mm5_g) AT=26.300000000n
.measure tran h024w13 FIND v(xdut.n_wl<13>_xarray/xi13/xi36/mm5_g) AT=26.300000000n
.measure tran h024w14 FIND v(xdut.n_wl<14>_xarray/xi14/xi36/mm5_g) AT=26.300000000n
.measure tran h024w15 FIND v(xdut.n_wl<15>_xarray/xi15/xi36/mm5_g) AT=26.300000000n
.measure tran l024 FIND v(xdut.n_wl<15>_xarray/xi15/xi36/mm5_g) AT=26.940000000n
.measure tran h025w00 FIND v(xdut.n_wl<0>_xarray/xi0/xi36/mm5_g) AT=27.300000000n
.measure tran h025w01 FIND v(xdut.n_wl<1>_xarray/xi1/xi36/mm5_g) AT=27.300000000n
.measure tran h025w02 FIND v(xdut.n_wl<2>_xarray/xi2/xi36/mm5_g) AT=27.300000000n
.measure tran h025w03 FIND v(xdut.n_wl<3>_xarray/xi3/xi36/mm5_g) AT=27.300000000n
.measure tran h025w04 FIND v(xdut.n_wl<4>_xarray/xi4/xi36/mm5_g) AT=27.300000000n
.measure tran h025w05 FIND v(xdut.n_wl<5>_xarray/xi5/xi36/mm5_g) AT=27.300000000n
.measure tran h025w06 FIND v(xdut.n_wl<6>_xarray/xi6/xi36/mm5_g) AT=27.300000000n
.measure tran h025w07 FIND v(xdut.n_wl<7>_xarray/xi7/xi36/mm5_g) AT=27.300000000n
.measure tran h025w08 FIND v(xdut.n_wl<8>_xarray/xi8/xi36/mm5_g) AT=27.300000000n
.measure tran h025w09 FIND v(xdut.n_wl<9>_xarray/xi9/xi36/mm5_g) AT=27.300000000n
.measure tran h025w10 FIND v(xdut.n_wl<10>_xarray/xi10/xi36/mm5_g) AT=27.300000000n
.measure tran h025w11 FIND v(xdut.n_wl<11>_xarray/xi11/xi36/mm5_g) AT=27.300000000n
.measure tran h025w12 FIND v(xdut.n_wl<12>_xarray/xi12/xi36/mm5_g) AT=27.300000000n
.measure tran h025w13 FIND v(xdut.n_wl<13>_xarray/xi13/xi36/mm5_g) AT=27.300000000n
.measure tran h025w14 FIND v(xdut.n_wl<14>_xarray/xi14/xi36/mm5_g) AT=27.300000000n
.measure tran h025w15 FIND v(xdut.n_wl<15>_xarray/xi15/xi36/mm5_g) AT=27.300000000n
.measure tran l025 FIND v(xdut.n_wl<15>_xarray/xi15/xi36/mm5_g) AT=27.940000000n
.measure tran h026w00 FIND v(xdut.n_wl<0>_xarray/xi0/xi36/mm5_g) AT=28.300000000n
.measure tran h026w01 FIND v(xdut.n_wl<1>_xarray/xi1/xi36/mm5_g) AT=28.300000000n
.measure tran h026w02 FIND v(xdut.n_wl<2>_xarray/xi2/xi36/mm5_g) AT=28.300000000n
.measure tran h026w03 FIND v(xdut.n_wl<3>_xarray/xi3/xi36/mm5_g) AT=28.300000000n
.measure tran h026w04 FIND v(xdut.n_wl<4>_xarray/xi4/xi36/mm5_g) AT=28.300000000n
.measure tran h026w05 FIND v(xdut.n_wl<5>_xarray/xi5/xi36/mm5_g) AT=28.300000000n
.measure tran h026w06 FIND v(xdut.n_wl<6>_xarray/xi6/xi36/mm5_g) AT=28.300000000n
.measure tran h026w07 FIND v(xdut.n_wl<7>_xarray/xi7/xi36/mm5_g) AT=28.300000000n
.measure tran h026w08 FIND v(xdut.n_wl<8>_xarray/xi8/xi36/mm5_g) AT=28.300000000n
.measure tran h026w09 FIND v(xdut.n_wl<9>_xarray/xi9/xi36/mm5_g) AT=28.300000000n
.measure tran h026w10 FIND v(xdut.n_wl<10>_xarray/xi10/xi36/mm5_g) AT=28.300000000n
.measure tran h026w11 FIND v(xdut.n_wl<11>_xarray/xi11/xi36/mm5_g) AT=28.300000000n
.measure tran h026w12 FIND v(xdut.n_wl<12>_xarray/xi12/xi36/mm5_g) AT=28.300000000n
.measure tran h026w13 FIND v(xdut.n_wl<13>_xarray/xi13/xi36/mm5_g) AT=28.300000000n
.measure tran h026w14 FIND v(xdut.n_wl<14>_xarray/xi14/xi36/mm5_g) AT=28.300000000n
.measure tran h026w15 FIND v(xdut.n_wl<15>_xarray/xi15/xi36/mm5_g) AT=28.300000000n
.measure tran l026 FIND v(xdut.n_wl<15>_xarray/xi15/xi36/mm5_g) AT=28.940000000n
.measure tran h027w00 FIND v(xdut.n_wl<0>_xarray/xi0/xi36/mm5_g) AT=29.300000000n
.measure tran h027w01 FIND v(xdut.n_wl<1>_xarray/xi1/xi36/mm5_g) AT=29.300000000n
.measure tran h027w02 FIND v(xdut.n_wl<2>_xarray/xi2/xi36/mm5_g) AT=29.300000000n
.measure tran h027w03 FIND v(xdut.n_wl<3>_xarray/xi3/xi36/mm5_g) AT=29.300000000n
.measure tran h027w04 FIND v(xdut.n_wl<4>_xarray/xi4/xi36/mm5_g) AT=29.300000000n
.measure tran h027w05 FIND v(xdut.n_wl<5>_xarray/xi5/xi36/mm5_g) AT=29.300000000n
.measure tran h027w06 FIND v(xdut.n_wl<6>_xarray/xi6/xi36/mm5_g) AT=29.300000000n
.measure tran h027w07 FIND v(xdut.n_wl<7>_xarray/xi7/xi36/mm5_g) AT=29.300000000n
.measure tran h027w08 FIND v(xdut.n_wl<8>_xarray/xi8/xi36/mm5_g) AT=29.300000000n
.measure tran h027w09 FIND v(xdut.n_wl<9>_xarray/xi9/xi36/mm5_g) AT=29.300000000n
.measure tran h027w10 FIND v(xdut.n_wl<10>_xarray/xi10/xi36/mm5_g) AT=29.300000000n
.measure tran h027w11 FIND v(xdut.n_wl<11>_xarray/xi11/xi36/mm5_g) AT=29.300000000n
.measure tran h027w12 FIND v(xdut.n_wl<12>_xarray/xi12/xi36/mm5_g) AT=29.300000000n
.measure tran h027w13 FIND v(xdut.n_wl<13>_xarray/xi13/xi36/mm5_g) AT=29.300000000n
.measure tran h027w14 FIND v(xdut.n_wl<14>_xarray/xi14/xi36/mm5_g) AT=29.300000000n
.measure tran h027w15 FIND v(xdut.n_wl<15>_xarray/xi15/xi36/mm5_g) AT=29.300000000n
.measure tran l027 FIND v(xdut.n_wl<15>_xarray/xi15/xi36/mm5_g) AT=29.940000000n
.measure tran h028w00 FIND v(xdut.n_wl<0>_xarray/xi0/xi36/mm5_g) AT=30.300000000n
.measure tran h028w01 FIND v(xdut.n_wl<1>_xarray/xi1/xi36/mm5_g) AT=30.300000000n
.measure tran h028w02 FIND v(xdut.n_wl<2>_xarray/xi2/xi36/mm5_g) AT=30.300000000n
.measure tran h028w03 FIND v(xdut.n_wl<3>_xarray/xi3/xi36/mm5_g) AT=30.300000000n
.measure tran h028w04 FIND v(xdut.n_wl<4>_xarray/xi4/xi36/mm5_g) AT=30.300000000n
.measure tran h028w05 FIND v(xdut.n_wl<5>_xarray/xi5/xi36/mm5_g) AT=30.300000000n
.measure tran h028w06 FIND v(xdut.n_wl<6>_xarray/xi6/xi36/mm5_g) AT=30.300000000n
.measure tran h028w07 FIND v(xdut.n_wl<7>_xarray/xi7/xi36/mm5_g) AT=30.300000000n
.measure tran h028w08 FIND v(xdut.n_wl<8>_xarray/xi8/xi36/mm5_g) AT=30.300000000n
.measure tran h028w09 FIND v(xdut.n_wl<9>_xarray/xi9/xi36/mm5_g) AT=30.300000000n
.measure tran h028w10 FIND v(xdut.n_wl<10>_xarray/xi10/xi36/mm5_g) AT=30.300000000n
.measure tran h028w11 FIND v(xdut.n_wl<11>_xarray/xi11/xi36/mm5_g) AT=30.300000000n
.measure tran h028w12 FIND v(xdut.n_wl<12>_xarray/xi12/xi36/mm5_g) AT=30.300000000n
.measure tran h028w13 FIND v(xdut.n_wl<13>_xarray/xi13/xi36/mm5_g) AT=30.300000000n
.measure tran h028w14 FIND v(xdut.n_wl<14>_xarray/xi14/xi36/mm5_g) AT=30.300000000n
.measure tran h028w15 FIND v(xdut.n_wl<15>_xarray/xi15/xi36/mm5_g) AT=30.300000000n
.measure tran l028 FIND v(xdut.n_wl<15>_xarray/xi15/xi36/mm5_g) AT=30.940000000n
.measure tran h029w00 FIND v(xdut.n_wl<0>_xarray/xi0/xi36/mm5_g) AT=31.300000000n
.measure tran h029w01 FIND v(xdut.n_wl<1>_xarray/xi1/xi36/mm5_g) AT=31.300000000n
.measure tran h029w02 FIND v(xdut.n_wl<2>_xarray/xi2/xi36/mm5_g) AT=31.300000000n
.measure tran h029w03 FIND v(xdut.n_wl<3>_xarray/xi3/xi36/mm5_g) AT=31.300000000n
.measure tran h029w04 FIND v(xdut.n_wl<4>_xarray/xi4/xi36/mm5_g) AT=31.300000000n
.measure tran h029w05 FIND v(xdut.n_wl<5>_xarray/xi5/xi36/mm5_g) AT=31.300000000n
.measure tran h029w06 FIND v(xdut.n_wl<6>_xarray/xi6/xi36/mm5_g) AT=31.300000000n
.measure tran h029w07 FIND v(xdut.n_wl<7>_xarray/xi7/xi36/mm5_g) AT=31.300000000n
.measure tran h029w08 FIND v(xdut.n_wl<8>_xarray/xi8/xi36/mm5_g) AT=31.300000000n
.measure tran h029w09 FIND v(xdut.n_wl<9>_xarray/xi9/xi36/mm5_g) AT=31.300000000n
.measure tran h029w10 FIND v(xdut.n_wl<10>_xarray/xi10/xi36/mm5_g) AT=31.300000000n
.measure tran h029w11 FIND v(xdut.n_wl<11>_xarray/xi11/xi36/mm5_g) AT=31.300000000n
.measure tran h029w12 FIND v(xdut.n_wl<12>_xarray/xi12/xi36/mm5_g) AT=31.300000000n
.measure tran h029w13 FIND v(xdut.n_wl<13>_xarray/xi13/xi36/mm5_g) AT=31.300000000n
.measure tran h029w14 FIND v(xdut.n_wl<14>_xarray/xi14/xi36/mm5_g) AT=31.300000000n
.measure tran h029w15 FIND v(xdut.n_wl<15>_xarray/xi15/xi36/mm5_g) AT=31.300000000n
.measure tran l029 FIND v(xdut.n_wl<15>_xarray/xi15/xi36/mm5_g) AT=31.940000000n
.measure tran h030w00 FIND v(xdut.n_wl<0>_xarray/xi0/xi36/mm5_g) AT=32.300000000n
.measure tran h030w01 FIND v(xdut.n_wl<1>_xarray/xi1/xi36/mm5_g) AT=32.300000000n
.measure tran h030w02 FIND v(xdut.n_wl<2>_xarray/xi2/xi36/mm5_g) AT=32.300000000n
.measure tran h030w03 FIND v(xdut.n_wl<3>_xarray/xi3/xi36/mm5_g) AT=32.300000000n
.measure tran h030w04 FIND v(xdut.n_wl<4>_xarray/xi4/xi36/mm5_g) AT=32.300000000n
.measure tran h030w05 FIND v(xdut.n_wl<5>_xarray/xi5/xi36/mm5_g) AT=32.300000000n
.measure tran h030w06 FIND v(xdut.n_wl<6>_xarray/xi6/xi36/mm5_g) AT=32.300000000n
.measure tran h030w07 FIND v(xdut.n_wl<7>_xarray/xi7/xi36/mm5_g) AT=32.300000000n
.measure tran h030w08 FIND v(xdut.n_wl<8>_xarray/xi8/xi36/mm5_g) AT=32.300000000n
.measure tran h030w09 FIND v(xdut.n_wl<9>_xarray/xi9/xi36/mm5_g) AT=32.300000000n
.measure tran h030w10 FIND v(xdut.n_wl<10>_xarray/xi10/xi36/mm5_g) AT=32.300000000n
.measure tran h030w11 FIND v(xdut.n_wl<11>_xarray/xi11/xi36/mm5_g) AT=32.300000000n
.measure tran h030w12 FIND v(xdut.n_wl<12>_xarray/xi12/xi36/mm5_g) AT=32.300000000n
.measure tran h030w13 FIND v(xdut.n_wl<13>_xarray/xi13/xi36/mm5_g) AT=32.300000000n
.measure tran h030w14 FIND v(xdut.n_wl<14>_xarray/xi14/xi36/mm5_g) AT=32.300000000n
.measure tran h030w15 FIND v(xdut.n_wl<15>_xarray/xi15/xi36/mm5_g) AT=32.300000000n
.measure tran l030 FIND v(xdut.n_wl<15>_xarray/xi15/xi36/mm5_g) AT=32.940000000n
.measure tran h031w00 FIND v(xdut.n_wl<0>_xarray/xi0/xi36/mm5_g) AT=33.300000000n
.measure tran h031w01 FIND v(xdut.n_wl<1>_xarray/xi1/xi36/mm5_g) AT=33.300000000n
.measure tran h031w02 FIND v(xdut.n_wl<2>_xarray/xi2/xi36/mm5_g) AT=33.300000000n
.measure tran h031w03 FIND v(xdut.n_wl<3>_xarray/xi3/xi36/mm5_g) AT=33.300000000n
.measure tran h031w04 FIND v(xdut.n_wl<4>_xarray/xi4/xi36/mm5_g) AT=33.300000000n
.measure tran h031w05 FIND v(xdut.n_wl<5>_xarray/xi5/xi36/mm5_g) AT=33.300000000n
.measure tran h031w06 FIND v(xdut.n_wl<6>_xarray/xi6/xi36/mm5_g) AT=33.300000000n
.measure tran h031w07 FIND v(xdut.n_wl<7>_xarray/xi7/xi36/mm5_g) AT=33.300000000n
.measure tran h031w08 FIND v(xdut.n_wl<8>_xarray/xi8/xi36/mm5_g) AT=33.300000000n
.measure tran h031w09 FIND v(xdut.n_wl<9>_xarray/xi9/xi36/mm5_g) AT=33.300000000n
.measure tran h031w10 FIND v(xdut.n_wl<10>_xarray/xi10/xi36/mm5_g) AT=33.300000000n
.measure tran h031w11 FIND v(xdut.n_wl<11>_xarray/xi11/xi36/mm5_g) AT=33.300000000n
.measure tran h031w12 FIND v(xdut.n_wl<12>_xarray/xi12/xi36/mm5_g) AT=33.300000000n
.measure tran h031w13 FIND v(xdut.n_wl<13>_xarray/xi13/xi36/mm5_g) AT=33.300000000n
.measure tran h031w14 FIND v(xdut.n_wl<14>_xarray/xi14/xi36/mm5_g) AT=33.300000000n
.measure tran h031w15 FIND v(xdut.n_wl<15>_xarray/xi15/xi36/mm5_g) AT=33.300000000n
.measure tran l031 FIND v(xdut.n_wl<15>_xarray/xi15/xi36/mm5_g) AT=33.940000000n
.measure tran reg1b0 FIND v(rout0) AT=4.15n
.measure tran reg1b1 FIND v(rout1) AT=4.15n
.measure tran reg1b2 FIND v(rout2) AT=4.15n
.measure tran reg1b3 FIND v(rout3) AT=4.15n
.measure tran reg1b4 FIND v(rout4) AT=4.15n
.measure tran reg1b5 FIND v(rout5) AT=4.15n
.measure tran reg1b6 FIND v(rout6) AT=4.15n
.measure tran reg1b7 FIND v(rout7) AT=4.15n
.measure tran reg3b0 FIND v(rout0) AT=6.15n
.measure tran reg3b1 FIND v(rout1) AT=6.15n
.measure tran reg3b2 FIND v(rout2) AT=6.15n
.measure tran reg3b3 FIND v(rout3) AT=6.15n
.measure tran reg3b4 FIND v(rout4) AT=6.15n
.measure tran reg3b5 FIND v(rout5) AT=6.15n
.measure tran reg3b6 FIND v(rout6) AT=6.15n
.measure tran reg3b7 FIND v(rout7) AT=6.15n
.measure tran reg5b0 FIND v(rout0) AT=8.15n
.measure tran reg5b1 FIND v(rout1) AT=8.15n
.measure tran reg5b2 FIND v(rout2) AT=8.15n
.measure tran reg5b3 FIND v(rout3) AT=8.15n
.measure tran reg5b4 FIND v(rout4) AT=8.15n
.measure tran reg5b5 FIND v(rout5) AT=8.15n
.measure tran reg5b6 FIND v(rout6) AT=8.15n
.measure tran reg5b7 FIND v(rout7) AT=8.15n
.measure tran reg7b0 FIND v(rout0) AT=10.15n
.measure tran reg7b1 FIND v(rout1) AT=10.15n
.measure tran reg7b2 FIND v(rout2) AT=10.15n
.measure tran reg7b3 FIND v(rout3) AT=10.15n
.measure tran reg7b4 FIND v(rout4) AT=10.15n
.measure tran reg7b5 FIND v(rout5) AT=10.15n
.measure tran reg7b6 FIND v(rout6) AT=10.15n
.measure tran reg7b7 FIND v(rout7) AT=10.15n
.measure tran reg9b0 FIND v(rout0) AT=12.15n
.measure tran reg9b1 FIND v(rout1) AT=12.15n
.measure tran reg9b2 FIND v(rout2) AT=12.15n
.measure tran reg9b3 FIND v(rout3) AT=12.15n
.measure tran reg9b4 FIND v(rout4) AT=12.15n
.measure tran reg9b5 FIND v(rout5) AT=12.15n
.measure tran reg9b6 FIND v(rout6) AT=12.15n
.measure tran reg9b7 FIND v(rout7) AT=12.15n
.measure tran reg11b0 FIND v(rout0) AT=14.15n
.measure tran reg11b1 FIND v(rout1) AT=14.15n
.measure tran reg11b2 FIND v(rout2) AT=14.15n
.measure tran reg11b3 FIND v(rout3) AT=14.15n
.measure tran reg11b4 FIND v(rout4) AT=14.15n
.measure tran reg11b5 FIND v(rout5) AT=14.15n
.measure tran reg11b6 FIND v(rout6) AT=14.15n
.measure tran reg11b7 FIND v(rout7) AT=14.15n
.measure tran reg13b0 FIND v(rout0) AT=16.15n
.measure tran reg13b1 FIND v(rout1) AT=16.15n
.measure tran reg13b2 FIND v(rout2) AT=16.15n
.measure tran reg13b3 FIND v(rout3) AT=16.15n
.measure tran reg13b4 FIND v(rout4) AT=16.15n
.measure tran reg13b5 FIND v(rout5) AT=16.15n
.measure tran reg13b6 FIND v(rout6) AT=16.15n
.measure tran reg13b7 FIND v(rout7) AT=16.15n
.measure tran reg15b0 FIND v(rout0) AT=18.15n
.measure tran reg15b1 FIND v(rout1) AT=18.15n
.measure tran reg15b2 FIND v(rout2) AT=18.15n
.measure tran reg15b3 FIND v(rout3) AT=18.15n
.measure tran reg15b4 FIND v(rout4) AT=18.15n
.measure tran reg15b5 FIND v(rout5) AT=18.15n
.measure tran reg15b6 FIND v(rout6) AT=18.15n
.measure tran reg15b7 FIND v(rout7) AT=18.15n
.measure tran reg17b0 FIND v(rout0) AT=20.15n
.measure tran reg17b1 FIND v(rout1) AT=20.15n
.measure tran reg17b2 FIND v(rout2) AT=20.15n
.measure tran reg17b3 FIND v(rout3) AT=20.15n
.measure tran reg17b4 FIND v(rout4) AT=20.15n
.measure tran reg17b5 FIND v(rout5) AT=20.15n
.measure tran reg17b6 FIND v(rout6) AT=20.15n
.measure tran reg17b7 FIND v(rout7) AT=20.15n
.measure tran reg19b0 FIND v(rout0) AT=22.15n
.measure tran reg19b1 FIND v(rout1) AT=22.15n
.measure tran reg19b2 FIND v(rout2) AT=22.15n
.measure tran reg19b3 FIND v(rout3) AT=22.15n
.measure tran reg19b4 FIND v(rout4) AT=22.15n
.measure tran reg19b5 FIND v(rout5) AT=22.15n
.measure tran reg19b6 FIND v(rout6) AT=22.15n
.measure tran reg19b7 FIND v(rout7) AT=22.15n
.measure tran reg21b0 FIND v(rout0) AT=24.15n
.measure tran reg21b1 FIND v(rout1) AT=24.15n
.measure tran reg21b2 FIND v(rout2) AT=24.15n
.measure tran reg21b3 FIND v(rout3) AT=24.15n
.measure tran reg21b4 FIND v(rout4) AT=24.15n
.measure tran reg21b5 FIND v(rout5) AT=24.15n
.measure tran reg21b6 FIND v(rout6) AT=24.15n
.measure tran reg21b7 FIND v(rout7) AT=24.15n
.measure tran reg23b0 FIND v(rout0) AT=26.15n
.measure tran reg23b1 FIND v(rout1) AT=26.15n
.measure tran reg23b2 FIND v(rout2) AT=26.15n
.measure tran reg23b3 FIND v(rout3) AT=26.15n
.measure tran reg23b4 FIND v(rout4) AT=26.15n
.measure tran reg23b5 FIND v(rout5) AT=26.15n
.measure tran reg23b6 FIND v(rout6) AT=26.15n
.measure tran reg23b7 FIND v(rout7) AT=26.15n
.measure tran reg25b0 FIND v(rout0) AT=28.15n
.measure tran reg25b1 FIND v(rout1) AT=28.15n
.measure tran reg25b2 FIND v(rout2) AT=28.15n
.measure tran reg25b3 FIND v(rout3) AT=28.15n
.measure tran reg25b4 FIND v(rout4) AT=28.15n
.measure tran reg25b5 FIND v(rout5) AT=28.15n
.measure tran reg25b6 FIND v(rout6) AT=28.15n
.measure tran reg25b7 FIND v(rout7) AT=28.15n
.measure tran reg27b0 FIND v(rout0) AT=30.15n
.measure tran reg27b1 FIND v(rout1) AT=30.15n
.measure tran reg27b2 FIND v(rout2) AT=30.15n
.measure tran reg27b3 FIND v(rout3) AT=30.15n
.measure tran reg27b4 FIND v(rout4) AT=30.15n
.measure tran reg27b5 FIND v(rout5) AT=30.15n
.measure tran reg27b6 FIND v(rout6) AT=30.15n
.measure tran reg27b7 FIND v(rout7) AT=30.15n
.measure tran reg29b0 FIND v(rout0) AT=32.15n
.measure tran reg29b1 FIND v(rout1) AT=32.15n
.measure tran reg29b2 FIND v(rout2) AT=32.15n
.measure tran reg29b3 FIND v(rout3) AT=32.15n
.measure tran reg29b4 FIND v(rout4) AT=32.15n
.measure tran reg29b5 FIND v(rout5) AT=32.15n
.measure tran reg29b6 FIND v(rout6) AT=32.15n
.measure tran reg29b7 FIND v(rout7) AT=32.15n
.measure tran reg31b0 FIND v(rout0) AT=34.15n
.measure tran reg31b1 FIND v(rout1) AT=34.15n
.measure tran reg31b2 FIND v(rout2) AT=34.15n
.measure tran reg31b3 FIND v(rout3) AT=34.15n
.measure tran reg31b4 FIND v(rout4) AT=34.15n
.measure tran reg31b5 FIND v(rout5) AT=34.15n
.measure tran reg31b6 FIND v(rout6) AT=34.15n
.measure tran reg31b7 FIND v(rout7) AT=34.15n
.measure tran isupply AVG i(V_SUP) FROM=2n TO=34.0n
.end
